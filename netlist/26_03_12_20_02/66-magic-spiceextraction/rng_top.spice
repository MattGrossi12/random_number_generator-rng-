* NGSPICE file created from rng_top.ext - technology: sky130A

* Black-box entry subcircuit for sky130_fd_sc_hd__fill_1 abstract view
.subckt sky130_fd_sc_hd__fill_1 VGND VNB VPB VPWR
.ends

* Black-box entry subcircuit for sky130_ef_sc_hd__decap_40_12 abstract view
.subckt sky130_ef_sc_hd__decap_40_12 VPWR VGND VPB VNB
.ends

* Black-box entry subcircuit for sky130_fd_sc_hd__fill_2 abstract view
.subckt sky130_fd_sc_hd__fill_2 VGND VNB VPB VPWR
.ends

* Black-box entry subcircuit for sky130_fd_sc_hd__decap_3 abstract view
.subckt sky130_fd_sc_hd__decap_3 VGND VNB VPB VPWR
.ends

* Black-box entry subcircuit for sky130_fd_sc_hd__mux2_1 abstract view
.subckt sky130_fd_sc_hd__mux2_1 A0 A1 S VGND VNB VPB VPWR X
.ends

* Black-box entry subcircuit for sky130_fd_sc_hd__a221o_1 abstract view
.subckt sky130_fd_sc_hd__a221o_1 A1 A2 B1 B2 C1 VGND VNB VPB VPWR X
.ends

* Black-box entry subcircuit for sky130_fd_sc_hd__clkbuf_4 abstract view
.subckt sky130_fd_sc_hd__clkbuf_4 A VGND VNB VPB VPWR X
.ends

* Black-box entry subcircuit for sky130_fd_sc_hd__dlygate4sd3_1 abstract view
.subckt sky130_fd_sc_hd__dlygate4sd3_1 A VGND VNB VPB VPWR X
.ends

* Black-box entry subcircuit for sky130_fd_sc_hd__fill_4 abstract view
.subckt sky130_fd_sc_hd__fill_4 VGND VNB VPB VPWR
.ends

* Black-box entry subcircuit for sky130_fd_sc_hd__or2_1 abstract view
.subckt sky130_fd_sc_hd__or2_1 A B VGND VNB VPB VPWR X
.ends

* Black-box entry subcircuit for sky130_fd_sc_hd__tapvpwrvgnd_1 abstract view
.subckt sky130_fd_sc_hd__tapvpwrvgnd_1 VGND VPWR
.ends

* Black-box entry subcircuit for sky130_fd_sc_hd__dfrtp_1 abstract view
.subckt sky130_fd_sc_hd__dfrtp_1 CLK D RESET_B VGND VNB VPB VPWR Q
.ends

* Black-box entry subcircuit for sky130_fd_sc_hd__nand2_1 abstract view
.subckt sky130_fd_sc_hd__nand2_1 A B VGND VNB VPB VPWR Y
.ends

* Black-box entry subcircuit for sky130_fd_sc_hd__buf_2 abstract view
.subckt sky130_fd_sc_hd__buf_2 A VGND VNB VPB VPWR X
.ends

* Black-box entry subcircuit for sky130_fd_sc_hd__clkbuf_16 abstract view
.subckt sky130_fd_sc_hd__clkbuf_16 A VGND VNB VPB VPWR X
.ends

* Black-box entry subcircuit for sky130_fd_sc_hd__xor2_1 abstract view
.subckt sky130_fd_sc_hd__xor2_1 A B VGND VNB VPB VPWR X
.ends

* Black-box entry subcircuit for sky130_fd_sc_hd__clkinv_2 abstract view
.subckt sky130_fd_sc_hd__clkinv_2 A VGND VNB VPB VPWR Y
.ends

* Black-box entry subcircuit for sky130_fd_sc_hd__clkinvlp_4 abstract view
.subckt sky130_fd_sc_hd__clkinvlp_4 A VGND VNB VPB VPWR Y
.ends

* Black-box entry subcircuit for sky130_fd_sc_hd__fill_8 abstract view
.subckt sky130_fd_sc_hd__fill_8 VGND VNB VPB VPWR
.ends

* Black-box entry subcircuit for sky130_fd_sc_hd__a211o_1 abstract view
.subckt sky130_fd_sc_hd__a211o_1 A1 A2 B1 C1 VGND VNB VPB VPWR X
.ends

* Black-box entry subcircuit for sky130_fd_sc_hd__dfrtp_2 abstract view
.subckt sky130_fd_sc_hd__dfrtp_2 CLK D RESET_B VGND VNB VPB VPWR Q
.ends

* Black-box entry subcircuit for sky130_fd_sc_hd__buf_1 abstract view
.subckt sky130_fd_sc_hd__buf_1 A VGND VNB VPB VPWR X
.ends

* Black-box entry subcircuit for sky130_fd_sc_hd__and2b_1 abstract view
.subckt sky130_fd_sc_hd__and2b_1 A_N B VGND VNB VPB VPWR X
.ends

* Black-box entry subcircuit for sky130_fd_sc_hd__a22o_1 abstract view
.subckt sky130_fd_sc_hd__a22o_1 A1 A2 B1 B2 VGND VNB VPB VPWR X
.ends

* Black-box entry subcircuit for sky130_fd_sc_hd__inv_2 abstract view
.subckt sky130_fd_sc_hd__inv_2 A VGND VNB VPB VPWR Y
.ends

* Black-box entry subcircuit for sky130_fd_sc_hd__and4b_1 abstract view
.subckt sky130_fd_sc_hd__and4b_1 A_N B C D VGND VNB VPB VPWR X
.ends

* Black-box entry subcircuit for sky130_fd_sc_hd__o2111a_1 abstract view
.subckt sky130_fd_sc_hd__o2111a_1 A1 A2 B1 C1 D1 VGND VNB VPB VPWR X
.ends

* Black-box entry subcircuit for sky130_fd_sc_hd__o311a_1 abstract view
.subckt sky130_fd_sc_hd__o311a_1 A1 A2 A3 B1 C1 VGND VNB VPB VPWR X
.ends

* Black-box entry subcircuit for sky130_fd_sc_hd__nor2_1 abstract view
.subckt sky130_fd_sc_hd__nor2_1 A B VGND VNB VPB VPWR Y
.ends

* Black-box entry subcircuit for sky130_fd_sc_hd__o211a_1 abstract view
.subckt sky130_fd_sc_hd__o211a_1 A1 A2 B1 C1 VGND VNB VPB VPWR X
.ends

* Black-box entry subcircuit for sky130_fd_sc_hd__and2_1 abstract view
.subckt sky130_fd_sc_hd__and2_1 A B VGND VNB VPB VPWR X
.ends

* Black-box entry subcircuit for sky130_fd_sc_hd__or3_1 abstract view
.subckt sky130_fd_sc_hd__or3_1 A B C VGND VNB VPB VPWR X
.ends

* Black-box entry subcircuit for sky130_fd_sc_hd__o21ai_1 abstract view
.subckt sky130_fd_sc_hd__o21ai_1 A1 A2 B1 VGND VNB VPB VPWR Y
.ends

* Black-box entry subcircuit for sky130_fd_sc_hd__o221a_1 abstract view
.subckt sky130_fd_sc_hd__o221a_1 A1 A2 B1 B2 C1 VGND VNB VPB VPWR X
.ends

* Black-box entry subcircuit for sky130_fd_sc_hd__a221oi_1 abstract view
.subckt sky130_fd_sc_hd__a221oi_1 A1 A2 B1 B2 C1 VGND VNB VPB VPWR Y
.ends

.subckt rng_top VGND VPWR clk_i num_to_send_o[0] num_to_send_o[1] num_to_send_o[2]
+ req_num_i rst_i wr_i
XFILLER_22_111 VGND VGND VPWR VPWR sky130_fd_sc_hd__fill_1
XFILLER_7_7 VPWR VGND VPWR VGND sky130_ef_sc_hd__decap_40_12
XFILLER_13_122 VGND VGND VPWR VPWR sky130_fd_sc_hd__fill_2
XPHY_EDGE_ROW_0_Left_23 VGND VGND VPWR VPWR sky130_fd_sc_hd__decap_3
X_131_ net25 rng_rd.ram_6\[0\] net8 VGND VGND VPWR VPWR _005_ sky130_fd_sc_hd__mux2_1
XFILLER_2_121 VGND VGND VPWR VPWR sky130_fd_sc_hd__fill_1
XFILLER_18_97 VPWR VGND VPWR VGND sky130_ef_sc_hd__decap_40_12
X_114_ _078_ _079_ _032_ _033_ _080_ VGND VGND VPWR VPWR _034_ sky130_fd_sc_hd__a221o_1
Xfanout7 net9 VGND VGND VPWR VPWR net7 sky130_fd_sc_hd__clkbuf_4
XFILLER_20_65 VGND VGND VPWR VPWR sky130_fd_sc_hd__fill_1
Xhold30 rng_rd.ram_5\[2\] VGND VGND VPWR VPWR net46 sky130_fd_sc_hd__dlygate4sd3_1
XFILLER_13_3 VGND VGND VPWR VPWR sky130_fd_sc_hd__fill_4
XFILLER_17_109 VGND VGND VPWR VPWR sky130_fd_sc_hd__fill_2
XFILLER_16_120 VGND VGND VPWR VPWR sky130_fd_sc_hd__fill_4
XFILLER_3_68 VGND VGND VPWR VPWR sky130_fd_sc_hd__fill_1
XFILLER_3_57 VGND VGND VPWR VPWR sky130_fd_sc_hd__fill_2
XFILLER_13_101 VGND VGND VPWR VPWR sky130_fd_sc_hd__fill_1
XFILLER_12_33 VGND VGND VPWR VPWR sky130_fd_sc_hd__fill_1
XPHY_EDGE_ROW_21_Right_21 VGND VGND VPWR VPWR sky130_fd_sc_hd__decap_3
X_130_ rng_rd.cache\[2\] net19 net3 VGND VGND VPWR VPWR _004_ sky130_fd_sc_hd__mux2_1
XPHY_EDGE_ROW_12_Right_12 VGND VGND VPWR VPWR sky130_fd_sc_hd__decap_3
XFILLER_9_23 VGND VGND VPWR VPWR sky130_fd_sc_hd__fill_4
X_113_ rng_rd.cache\[0\] rng_rd.ram_2\[0\] VGND VGND VPWR VPWR _033_ sky130_fd_sc_hd__or2_1
Xfanout8 net9 VGND VGND VPWR VPWR net8 sky130_fd_sc_hd__clkbuf_4
XTAP_TAPCELL_ROW_20_88 VGND VPWR sky130_fd_sc_hd__tapvpwrvgnd_1
Xhold20 rng_rd.ram_6\[2\] VGND VGND VPWR VPWR net36 sky130_fd_sc_hd__dlygate4sd3_1
Xhold31 rng_rd.ram_6\[0\] VGND VGND VPWR VPWR net47 sky130_fd_sc_hd__dlygate4sd3_1
XPHY_EDGE_ROW_6_Right_6 VGND VGND VPWR VPWR sky130_fd_sc_hd__decap_3
XFILLER_15_44 VGND VGND VPWR VPWR sky130_fd_sc_hd__fill_4
XFILLER_22_113 VPWR VGND VPWR VGND sky130_ef_sc_hd__decap_40_12
XFILLER_13_124 VGND VGND VPWR VPWR sky130_fd_sc_hd__fill_1
XFILLER_3_3 VGND VGND VPWR VPWR sky130_fd_sc_hd__fill_4
XFILLER_0_37 VGND VGND VPWR VPWR sky130_fd_sc_hd__fill_4
XFILLER_0_15 VPWR VGND VPWR VGND sky130_ef_sc_hd__decap_40_12
X_189_ clknet_2_2__leaf_clk_i _026_ net16 VGND VGND VPWR VPWR num_i_bar\[0\] sky130_fd_sc_hd__dfrtp_1
XTAP_TAPCELL_ROW_5_58 VGND VPWR sky130_fd_sc_hd__tapvpwrvgnd_1
X_112_ net12 rng_rd.ram_2\[0\] VGND VGND VPWR VPWR _032_ sky130_fd_sc_hd__nand2_1
Xfanout9 _045_ VGND VGND VPWR VPWR net9 sky130_fd_sc_hd__buf_2
XTAP_TAPCELL_ROW_20_89 VGND VPWR sky130_fd_sc_hd__tapvpwrvgnd_1
Xclkbuf_2_0__f_clk_i clknet_0_clk_i VGND VGND VPWR VPWR clknet_2_0__leaf_clk_i sky130_fd_sc_hd__clkbuf_16
Xhold32 rng_rd.ram_3\[1\] VGND VGND VPWR VPWR net48 sky130_fd_sc_hd__dlygate4sd3_1
XFILLER_6_58 VGND VGND VPWR VPWR sky130_fd_sc_hd__fill_2
Xhold21 _031_ VGND VGND VPWR VPWR net37 sky130_fd_sc_hd__dlygate4sd3_1
Xhold10 _005_ VGND VGND VPWR VPWR net26 sky130_fd_sc_hd__dlygate4sd3_1
XPHY_EDGE_ROW_16_Left_39 VGND VGND VPWR VPWR sky130_fd_sc_hd__decap_3
XTAP_TAPCELL_ROW_15_78 VGND VPWR sky130_fd_sc_hd__tapvpwrvgnd_1
XPHY_EDGE_ROW_19_Left_42 VGND VGND VPWR VPWR sky130_fd_sc_hd__decap_3
XFILLER_5_110 VGND VGND VPWR VPWR sky130_fd_sc_hd__fill_2
XPHY_EDGE_ROW_4_Left_27 VGND VGND VPWR VPWR sky130_fd_sc_hd__decap_3
XFILLER_0_27 VGND VGND VPWR VPWR sky130_fd_sc_hd__fill_1
X_188_ clknet_2_3__leaf_clk_i net18 net15 VGND VGND VPWR VPWR rng_rd.wr_ff2_d sky130_fd_sc_hd__dfrtp_1
X_111_ net11 rng_rd.ram_2\[1\] VGND VGND VPWR VPWR _080_ sky130_fd_sc_hd__xor2_1
XTAP_TAPCELL_ROW_5_59 VGND VPWR sky130_fd_sc_hd__tapvpwrvgnd_1
XFILLER_20_24 VGND VGND VPWR VPWR sky130_fd_sc_hd__fill_4
Xhold22 rng_rd.ram_2\[1\] VGND VGND VPWR VPWR net38 sky130_fd_sc_hd__dlygate4sd3_1
Xhold33 rng_rd.ram_4\[1\] VGND VGND VPWR VPWR net49 sky130_fd_sc_hd__dlygate4sd3_1
XPHY_EDGE_ROW_7_Left_30 VGND VGND VPWR VPWR sky130_fd_sc_hd__decap_3
XFILLER_6_26 VGND VGND VPWR VPWR sky130_fd_sc_hd__fill_2
Xhold11 num_i_bar\[1\] VGND VGND VPWR VPWR net27 sky130_fd_sc_hd__dlygate4sd3_1
XTAP_TAPCELL_ROW_15_79 VGND VPWR sky130_fd_sc_hd__tapvpwrvgnd_1
XFILLER_15_57 VGND VGND VPWR VPWR sky130_fd_sc_hd__fill_1
XFILLER_11_3 VGND VGND VPWR VPWR sky130_fd_sc_hd__fill_2
XFILLER_3_49 VGND VGND VPWR VPWR sky130_fd_sc_hd__fill_1
XFILLER_12_25 VGND VGND VPWR VPWR sky130_fd_sc_hd__fill_2
XPHY_EDGE_ROW_20_Left_43 VGND VGND VPWR VPWR sky130_fd_sc_hd__decap_3
X_187_ clknet_2_0__leaf_clk_i _025_ net13 VGND VGND VPWR VPWR net6 sky130_fd_sc_hd__dfrtp_1
X_110_ net10 rng_rd.ram_2\[2\] VGND VGND VPWR VPWR _079_ sky130_fd_sc_hd__nand2_1
Xclkload0 clknet_2_0__leaf_clk_i VGND VGND VPWR VPWR clkload0/X sky130_fd_sc_hd__clkbuf_4
Xhold34 rng_rd.ram_2\[2\] VGND VGND VPWR VPWR net50 sky130_fd_sc_hd__dlygate4sd3_1
Xhold23 rng_rd.ram_4\[0\] VGND VGND VPWR VPWR net39 sky130_fd_sc_hd__dlygate4sd3_1
Xhold12 rng_rd.ram_6\[1\] VGND VGND VPWR VPWR net28 sky130_fd_sc_hd__dlygate4sd3_1
XFILLER_19_110 VGND VGND VPWR VPWR sky130_fd_sc_hd__fill_2
XFILLER_6_49 VGND VGND VPWR VPWR sky130_fd_sc_hd__fill_4
XFILLER_13_7 VGND VGND VPWR VPWR sky130_fd_sc_hd__fill_2
XTAP_TAPCELL_ROW_21_90 VGND VPWR sky130_fd_sc_hd__tapvpwrvgnd_1
XPHY_EDGE_ROW_19_Right_19 VGND VGND VPWR VPWR sky130_fd_sc_hd__decap_3
XFILLER_16_124 VGND VGND VPWR VPWR sky130_fd_sc_hd__fill_1
XFILLER_3_39 VGND VGND VPWR VPWR sky130_fd_sc_hd__fill_1
XFILLER_12_15 VGND VGND VPWR VPWR sky130_fd_sc_hd__fill_2
X_186_ clknet_2_0__leaf_clk_i _024_ net13 VGND VGND VPWR VPWR net5 sky130_fd_sc_hd__dfrtp_1
XFILLER_9_27 VGND VGND VPWR VPWR sky130_fd_sc_hd__fill_1
Xclkload1 clknet_2_1__leaf_clk_i VGND VGND VPWR VPWR clkload1/Y sky130_fd_sc_hd__clkinv_2
X_169_ clknet_2_1__leaf_clk_i net45 net14 VGND VGND VPWR VPWR rng_rd.ram_5\[1\] sky130_fd_sc_hd__dfrtp_1
XFILLER_20_37 VGND VGND VPWR VPWR sky130_fd_sc_hd__fill_4
Xhold35 _019_ VGND VGND VPWR VPWR net51 sky130_fd_sc_hd__dlygate4sd3_1
Xhold24 rng_rd.ram_4\[2\] VGND VGND VPWR VPWR net40 sky130_fd_sc_hd__dlygate4sd3_1
Xhold13 _030_ VGND VGND VPWR VPWR net29 sky130_fd_sc_hd__dlygate4sd3_1
XTAP_TAPCELL_ROW_6_60 VGND VPWR sky130_fd_sc_hd__tapvpwrvgnd_1
XFILLER_15_15 VGND VGND VPWR VPWR sky130_fd_sc_hd__fill_2
XTAP_TAPCELL_ROW_21_91 VGND VPWR sky130_fd_sc_hd__tapvpwrvgnd_1
XFILLER_11_5 VGND VGND VPWR VPWR sky130_fd_sc_hd__fill_1
XFILLER_3_18 VGND VGND VPWR VPWR sky130_fd_sc_hd__fill_1
XTAP_TAPCELL_ROW_16_80 VGND VPWR sky130_fd_sc_hd__tapvpwrvgnd_1
XFILLER_12_27 VGND VGND VPWR VPWR sky130_fd_sc_hd__fill_1
XFILLER_5_113 VPWR VGND VPWR VGND sky130_ef_sc_hd__decap_40_12
Xclkbuf_2_3__f_clk_i clknet_0_clk_i VGND VGND VPWR VPWR clknet_2_3__leaf_clk_i sky130_fd_sc_hd__clkbuf_16
XFILLER_3_7 VGND VGND VPWR VPWR sky130_fd_sc_hd__fill_2
XFILLER_2_105 VPWR VGND VPWR VGND sky130_ef_sc_hd__decap_40_12
X_185_ clknet_2_0__leaf_clk_i _023_ net14 VGND VGND VPWR VPWR net4 sky130_fd_sc_hd__dfrtp_1
XFILLER_18_26 VGND VGND VPWR VPWR sky130_fd_sc_hd__fill_2
Xclkload2 clknet_2_3__leaf_clk_i VGND VGND VPWR VPWR clkload2/Y sky130_fd_sc_hd__clkinvlp_4
X_099_ net12 rng_rd.ram_4\[0\] VGND VGND VPWR VPWR _068_ sky130_fd_sc_hd__xor2_1
X_168_ clknet_2_2__leaf_clk_i _008_ net15 VGND VGND VPWR VPWR rng_rd.ram_5\[0\] sky130_fd_sc_hd__dfrtp_1
Xhold14 rng_rd.ram_2\[0\] VGND VGND VPWR VPWR net30 sky130_fd_sc_hd__dlygate4sd3_1
Xhold25 rng_rd.ram_1\[0\] VGND VGND VPWR VPWR net41 sky130_fd_sc_hd__dlygate4sd3_1
Xhold36 num_i_bar\[0\] VGND VGND VPWR VPWR net52 sky130_fd_sc_hd__dlygate4sd3_1
XFILLER_13_9 VGND VGND VPWR VPWR sky130_fd_sc_hd__fill_1
XTAP_TAPCELL_ROW_6_61 VGND VPWR sky130_fd_sc_hd__tapvpwrvgnd_1
XPHY_EDGE_ROW_1_Right_1 VGND VGND VPWR VPWR sky130_fd_sc_hd__decap_3
XFILLER_21_81 VPWR VGND VPWR VGND sky130_ef_sc_hd__decap_40_12
XTAP_TAPCELL_ROW_16_81 VGND VPWR sky130_fd_sc_hd__tapvpwrvgnd_1
XFILLER_2_117 VGND VGND VPWR VPWR sky130_fd_sc_hd__fill_4
X_184_ clknet_2_0__leaf_clk_i _022_ net13 VGND VGND VPWR VPWR rng_rd.ram_1\[2\] sky130_fd_sc_hd__dfrtp_1
XFILLER_18_49 VGND VGND VPWR VPWR sky130_fd_sc_hd__fill_2
X_098_ rng_rd.cache\[1\] rng_rd.ram_4\[1\] VGND VGND VPWR VPWR _067_ sky130_fd_sc_hd__nand2_1
X_167_ clknet_2_3__leaf_clk_i net24 net16 VGND VGND VPWR VPWR rng_rd.ram_7\[2\] sky130_fd_sc_hd__dfrtp_1
XFILLER_19_113 VPWR VGND VPWR VGND sky130_ef_sc_hd__decap_40_12
Xhold37 rng_rd.ram_1\[2\] VGND VGND VPWR VPWR net53 sky130_fd_sc_hd__dlygate4sd3_1
Xhold15 _017_ VGND VGND VPWR VPWR net31 sky130_fd_sc_hd__dlygate4sd3_1
XFILLER_10_83 VGND VGND VPWR VPWR sky130_fd_sc_hd__fill_1
Xhold26 _020_ VGND VGND VPWR VPWR net42 sky130_fd_sc_hd__dlygate4sd3_1
XPHY_EDGE_ROW_11_Left_34 VGND VGND VPWR VPWR sky130_fd_sc_hd__decap_3
XFILLER_15_17 VGND VGND VPWR VPWR sky130_fd_sc_hd__fill_1
XFILLER_21_93 VPWR VGND VPWR VGND sky130_ef_sc_hd__decap_40_12
XFILLER_7_73 VGND VGND VPWR VPWR sky130_fd_sc_hd__fill_4
XPHY_EDGE_ROW_15_Right_15 VGND VGND VPWR VPWR sky130_fd_sc_hd__decap_3
XFILLER_12_29 VGND VGND VPWR VPWR sky130_fd_sc_hd__fill_4
XFILLER_4_85 VGND VGND VPWR VPWR sky130_fd_sc_hd__fill_2
X_183_ clknet_2_0__leaf_clk_i _021_ net13 VGND VGND VPWR VPWR rng_rd.ram_1\[1\] sky130_fd_sc_hd__dfrtp_1
X_097_ rng_rd.cache\[1\] rng_rd.ram_4\[1\] VGND VGND VPWR VPWR _066_ sky130_fd_sc_hd__or2_1
X_166_ clknet_2_3__leaf_clk_i net22 net16 VGND VGND VPWR VPWR rng_rd.ram_7\[1\] sky130_fd_sc_hd__dfrtp_1
Xhold16 rng_rd.ram_1\[1\] VGND VGND VPWR VPWR net32 sky130_fd_sc_hd__dlygate4sd3_1
Xhold38 net4 VGND VGND VPWR VPWR net54 sky130_fd_sc_hd__dlygate4sd3_1
Xhold27 rng_rd.ram_5\[0\] VGND VGND VPWR VPWR net43 sky130_fd_sc_hd__dlygate4sd3_1
XFILLER_19_82 VPWR VGND VPWR VGND sky130_ef_sc_hd__decap_40_12
X_149_ net54 net12 net9 VGND VGND VPWR VPWR _023_ sky130_fd_sc_hd__mux2_1
XFILLER_21_61 VGND VGND VPWR VPWR sky130_fd_sc_hd__fill_2
XFILLER_22_109 VGND VGND VPWR VPWR sky130_fd_sc_hd__fill_2
XFILLER_8_113 VGND VGND VPWR VPWR sky130_fd_sc_hd__fill_4
XFILLER_4_20 VGND VGND VPWR VPWR sky130_fd_sc_hd__fill_8
X_182_ clknet_2_0__leaf_clk_i net42 net13 VGND VGND VPWR VPWR rng_rd.ram_1\[0\] sky130_fd_sc_hd__dfrtp_1
XFILLER_1_32 VGND VGND VPWR VPWR sky130_fd_sc_hd__fill_4
X_096_ _063_ _064_ _061_ _062_ VGND VGND VPWR VPWR _065_ sky130_fd_sc_hd__a211o_1
X_165_ clknet_2_3__leaf_clk_i net26 net15 VGND VGND VPWR VPWR rng_rd.ram_7\[0\] sky130_fd_sc_hd__dfrtp_1
Xhold17 rng_rd.ram_3\[2\] VGND VGND VPWR VPWR net33 sky130_fd_sc_hd__dlygate4sd3_1
Xhold39 net5 VGND VGND VPWR VPWR net55 sky130_fd_sc_hd__dlygate4sd3_1
Xhold28 rng_rd.ram_5\[1\] VGND VGND VPWR VPWR net44 sky130_fd_sc_hd__dlygate4sd3_1
XFILLER_19_94 VPWR VGND VPWR VGND sky130_ef_sc_hd__decap_40_12
XFILLER_19_61 VGND VGND VPWR VPWR sky130_fd_sc_hd__fill_1
XFILLER_19_50 VGND VGND VPWR VPWR sky130_fd_sc_hd__fill_4
X_148_ net53 net6 net7 VGND VGND VPWR VPWR _022_ sky130_fd_sc_hd__mux2_1
XFILLER_10_85 VPWR VGND VPWR VGND sky130_ef_sc_hd__decap_40_12
XPHY_EDGE_ROW_5_Right_5 VGND VGND VPWR VPWR sky130_fd_sc_hd__decap_3
XTAP_TAPCELL_ROW_3_54 VGND VPWR sky130_fd_sc_hd__tapvpwrvgnd_1
XFILLER_12_110 VGND VGND VPWR VPWR sky130_fd_sc_hd__fill_4
XFILLER_5_106 VGND VGND VPWR VPWR sky130_fd_sc_hd__fill_4
XFILLER_4_87 VGND VGND VPWR VPWR sky130_fd_sc_hd__fill_1
X_181_ clknet_2_2__leaf_clk_i net17 net15 VGND VGND VPWR VPWR rng_rd.wr_ff2 sky130_fd_sc_hd__dfrtp_1
XTAP_TAPCELL_ROW_13_74 VGND VPWR sky130_fd_sc_hd__tapvpwrvgnd_1
X_164_ clknet_2_2__leaf_clk_i _004_ net15 VGND VGND VPWR VPWR rng_rd.cache\[2\] sky130_fd_sc_hd__dfrtp_2
XFILLER_1_77 VPWR VGND VPWR VGND sky130_ef_sc_hd__decap_40_12
X_095_ net11 rng_rd.ram_5\[1\] VGND VGND VPWR VPWR _064_ sky130_fd_sc_hd__or2_1
Xhold18 _016_ VGND VGND VPWR VPWR net34 sky130_fd_sc_hd__dlygate4sd3_1
Xhold29 _009_ VGND VGND VPWR VPWR net45 sky130_fd_sc_hd__dlygate4sd3_1
XFILLER_10_53 VGND VGND VPWR VPWR sky130_fd_sc_hd__fill_2
XFILLER_10_97 VGND VGND VPWR VPWR sky130_fd_sc_hd__fill_4
X_147_ net32 net5 net7 VGND VGND VPWR VPWR _021_ sky130_fd_sc_hd__mux2_1
XPHY_EDGE_ROW_15_Left_38 VGND VGND VPWR VPWR sky130_fd_sc_hd__decap_3
XFILLER_21_111 VGND VGND VPWR VPWR sky130_fd_sc_hd__fill_1
XPHY_EDGE_ROW_20_Right_20 VGND VGND VPWR VPWR sky130_fd_sc_hd__decap_3
XTAP_TAPCELL_ROW_3_55 VGND VPWR sky130_fd_sc_hd__tapvpwrvgnd_1
XPHY_EDGE_ROW_11_Right_11 VGND VGND VPWR VPWR sky130_fd_sc_hd__decap_3
XFILLER_16_85 VGND VGND VPWR VPWR sky130_fd_sc_hd__fill_2
XPHY_EDGE_ROW_18_Left_41 VGND VGND VPWR VPWR sky130_fd_sc_hd__decap_3
X_180_ clknet_2_0__leaf_clk_i net51 net13 VGND VGND VPWR VPWR rng_rd.ram_2\[2\] sky130_fd_sc_hd__dfrtp_1
Xfanout10 rng_rd.cache\[2\] VGND VGND VPWR VPWR net10 sky130_fd_sc_hd__buf_2
XFILLER_13_97 VGND VGND VPWR VPWR sky130_fd_sc_hd__fill_4
XTAP_TAPCELL_ROW_13_75 VGND VPWR sky130_fd_sc_hd__tapvpwrvgnd_1
XPHY_EDGE_ROW_3_Left_26 VGND VGND VPWR VPWR sky130_fd_sc_hd__decap_3
X_094_ net11 rng_rd.ram_5\[1\] VGND VGND VPWR VPWR _063_ sky130_fd_sc_hd__nand2_1
X_163_ clknet_2_2__leaf_clk_i _003_ net15 VGND VGND VPWR VPWR rng_rd.cache\[1\] sky130_fd_sc_hd__dfrtp_1
XFILLER_1_89 VPWR VGND VPWR VGND sky130_ef_sc_hd__decap_40_12
Xhold19 rng_rd.ram_3\[0\] VGND VGND VPWR VPWR net35 sky130_fd_sc_hd__dlygate4sd3_1
XFILLER_19_106 VGND VGND VPWR VPWR sky130_fd_sc_hd__fill_4
XFILLER_10_65 VGND VGND VPWR VPWR sky130_fd_sc_hd__fill_4
X_146_ net41 net4 net7 VGND VGND VPWR VPWR _020_ sky130_fd_sc_hd__mux2_1
XFILLER_7_22 VGND VGND VPWR VPWR sky130_fd_sc_hd__fill_4
XFILLER_7_77 VGND VGND VPWR VPWR sky130_fd_sc_hd__fill_1
X_129_ net11 net27 net3 VGND VGND VPWR VPWR _003_ sky130_fd_sc_hd__mux2_1
Xfanout11 rng_rd.cache\[1\] VGND VGND VPWR VPWR net11 sky130_fd_sc_hd__clkbuf_4
XFILLER_1_111 VGND VGND VPWR VPWR sky130_fd_sc_hd__fill_1
XTAP_TAPCELL_ROW_0_46 VGND VPWR sky130_fd_sc_hd__tapvpwrvgnd_1
XFILLER_8_3 VGND VGND VPWR VPWR sky130_fd_sc_hd__fill_2
XTAP_TAPCELL_ROW_9_66 VGND VPWR sky130_fd_sc_hd__tapvpwrvgnd_1
Xclkbuf_0_clk_i clk_i VGND VGND VPWR VPWR clknet_0_clk_i sky130_fd_sc_hd__clkbuf_16
X_162_ clknet_2_2__leaf_clk_i _002_ net15 VGND VGND VPWR VPWR rng_rd.cache\[0\] sky130_fd_sc_hd__dfrtp_1
X_093_ net12 rng_rd.ram_5\[0\] VGND VGND VPWR VPWR _062_ sky130_fd_sc_hd__xor2_1
XTAP_TAPCELL_ROW_19_86 VGND VPWR sky130_fd_sc_hd__tapvpwrvgnd_1
XFILLER_10_33 VGND VGND VPWR VPWR sky130_fd_sc_hd__fill_2
XFILLER_10_55 VGND VGND VPWR VPWR sky130_fd_sc_hd__fill_1
Xinput1 req_num_i VGND VGND VPWR VPWR net1 sky130_fd_sc_hd__buf_1
X_145_ net50 rng_rd.ram_1\[2\] net7 VGND VGND VPWR VPWR _019_ sky130_fd_sc_hd__mux2_1
XFILLER_21_113 VPWR VGND VPWR VGND sky130_ef_sc_hd__decap_40_12
X_128_ net12 net52 net3 VGND VGND VPWR VPWR _002_ sky130_fd_sc_hd__mux2_1
XPHY_EDGE_ROW_9_Right_9 VGND VGND VPWR VPWR sky130_fd_sc_hd__decap_3
XFILLER_4_46 VGND VGND VPWR VPWR sky130_fd_sc_hd__fill_4
XFILLER_1_101 VGND VGND VPWR VPWR sky130_fd_sc_hd__fill_8
XTAP_TAPCELL_ROW_0_47 VGND VPWR sky130_fd_sc_hd__tapvpwrvgnd_1
XTAP_TAPCELL_ROW_9_67 VGND VPWR sky130_fd_sc_hd__tapvpwrvgnd_1
XFILLER_13_33 VGND VGND VPWR VPWR sky130_fd_sc_hd__fill_2
Xfanout12 rng_rd.cache\[0\] VGND VGND VPWR VPWR net12 sky130_fd_sc_hd__clkbuf_4
X_161_ net36 rng_rd.ram_5\[2\] net8 VGND VGND VPWR VPWR _031_ sky130_fd_sc_hd__mux2_1
X_092_ net10 rng_rd.ram_5\[2\] VGND VGND VPWR VPWR _061_ sky130_fd_sc_hd__xor2_1
XTAP_TAPCELL_ROW_19_87 VGND VPWR sky130_fd_sc_hd__tapvpwrvgnd_1
Xinput2 rst_i VGND VGND VPWR VPWR net2 sky130_fd_sc_hd__buf_1
XFILLER_19_54 VGND VGND VPWR VPWR sky130_fd_sc_hd__fill_2
X_144_ net38 net32 net7 VGND VGND VPWR VPWR _018_ sky130_fd_sc_hd__mux2_1
XFILLER_21_55 VGND VGND VPWR VPWR sky130_fd_sc_hd__fill_1
XFILLER_21_44 VGND VGND VPWR VPWR sky130_fd_sc_hd__fill_2
X_127_ net20 net18 VGND VGND VPWR VPWR _001_ sky130_fd_sc_hd__and2b_1
XFILLER_16_3 VGND VGND VPWR VPWR sky130_fd_sc_hd__fill_1
XFILLER_12_114 VGND VGND VPWR VPWR sky130_fd_sc_hd__fill_2
XFILLER_4_58 VGND VGND VPWR VPWR sky130_fd_sc_hd__fill_2
Xfanout13 net14 VGND VGND VPWR VPWR net13 sky130_fd_sc_hd__clkbuf_4
XFILLER_1_113 VPWR VGND VPWR VGND sky130_ef_sc_hd__decap_40_12
XTAP_TAPCELL_ROW_0_48 VGND VPWR sky130_fd_sc_hd__tapvpwrvgnd_1
X_160_ net28 rng_rd.ram_5\[1\] net8 VGND VGND VPWR VPWR _030_ sky130_fd_sc_hd__mux2_1
X_091_ _055_ _056_ _058_ _059_ VGND VGND VPWR VPWR _060_ sky130_fd_sc_hd__a22o_1
XPHY_EDGE_ROW_18_Right_18 VGND VGND VPWR VPWR sky130_fd_sc_hd__decap_3
Xinput3 wr_i VGND VGND VPWR VPWR net3 sky130_fd_sc_hd__buf_1
XTAP_TAPCELL_ROW_10_68 VGND VPWR sky130_fd_sc_hd__tapvpwrvgnd_1
X_143_ net30 rng_rd.ram_1\[0\] net9 VGND VGND VPWR VPWR _017_ sky130_fd_sc_hd__mux2_1
XFILLER_10_35 VGND VGND VPWR VPWR sky130_fd_sc_hd__fill_1
X_126_ net7 VGND VGND VPWR VPWR _000_ sky130_fd_sc_hd__inv_2
XPHY_EDGE_ROW_0_Right_0 VGND VGND VPWR VPWR sky130_fd_sc_hd__decap_3
XFILLER_16_56 VGND VGND VPWR VPWR sky130_fd_sc_hd__fill_8
X_109_ net10 rng_rd.ram_2\[2\] VGND VGND VPWR VPWR _078_ sky130_fd_sc_hd__or2_1
XTAP_TAPCELL_ROW_0_49 VGND VPWR sky130_fd_sc_hd__tapvpwrvgnd_1
Xfanout14 net2 VGND VGND VPWR VPWR net14 sky130_fd_sc_hd__clkbuf_4
XFILLER_13_13 VPWR VGND VPWR VGND sky130_ef_sc_hd__decap_40_12
XFILLER_13_35 VGND VGND VPWR VPWR sky130_fd_sc_hd__fill_1
X_090_ rng_rd.cache\[2\] rng_rd.ram_7\[2\] VGND VGND VPWR VPWR _059_ sky130_fd_sc_hd__or2_1
XTAP_TAPCELL_ROW_10_69 VGND VPWR sky130_fd_sc_hd__tapvpwrvgnd_1
X_142_ net33 rng_rd.ram_2\[2\] net8 VGND VGND VPWR VPWR _016_ sky130_fd_sc_hd__mux2_1
XFILLER_10_47 VGND VGND VPWR VPWR sky130_fd_sc_hd__fill_1
XFILLER_18_121 VGND VGND VPWR VPWR sky130_fd_sc_hd__fill_4
XFILLER_21_57 VGND VGND VPWR VPWR sky130_fd_sc_hd__fill_4
XFILLER_21_46 VGND VGND VPWR VPWR sky130_fd_sc_hd__fill_1
X_125_ _037_ _043_ _044_ rng_rd.wr_pulse VGND VGND VPWR VPWR _045_ sky130_fd_sc_hd__and4b_1
XFILLER_21_105 VGND VGND VPWR VPWR sky130_fd_sc_hd__fill_4
XPHY_EDGE_ROW_10_Left_33 VGND VGND VPWR VPWR sky130_fd_sc_hd__decap_3
XFILLER_12_116 VGND VGND VPWR VPWR sky130_fd_sc_hd__fill_1
XFILLER_16_46 VGND VGND VPWR VPWR sky130_fd_sc_hd__fill_4
XFILLER_21_3 VPWR VGND VPWR VGND sky130_ef_sc_hd__decap_40_12
X_108_ _073_ _074_ _075_ _076_ _072_ VGND VGND VPWR VPWR _077_ sky130_fd_sc_hd__a221o_1
XFILLER_13_25 VGND VGND VPWR VPWR sky130_fd_sc_hd__fill_8
Xfanout15 net16 VGND VGND VPWR VPWR net15 sky130_fd_sc_hd__clkbuf_4
XFILLER_19_57 VGND VGND VPWR VPWR sky130_fd_sc_hd__fill_4
X_141_ net48 net38 net8 VGND VGND VPWR VPWR _015_ sky130_fd_sc_hd__mux2_1
XFILLER_21_69 VPWR VGND VPWR VGND sky130_ef_sc_hd__decap_40_12
XFILLER_21_36 VGND VGND VPWR VPWR sky130_fd_sc_hd__fill_8
XFILLER_7_49 VGND VGND VPWR VPWR sky130_fd_sc_hd__fill_2
X_124_ _057_ _060_ _065_ _034_ _042_ VGND VGND VPWR VPWR _044_ sky130_fd_sc_hd__o2111a_1
Xclkbuf_2_2__f_clk_i clknet_0_clk_i VGND VGND VPWR VPWR clknet_2_2__leaf_clk_i sky130_fd_sc_hd__clkbuf_16
XFILLER_7_110 VGND VGND VPWR VPWR sky130_fd_sc_hd__fill_2
X_107_ net10 rng_rd.ram_1\[2\] VGND VGND VPWR VPWR _076_ sky130_fd_sc_hd__nand2_1
XFILLER_4_113 VPWR VGND VPWR VGND sky130_ef_sc_hd__decap_40_12
Xfanout16 net2 VGND VGND VPWR VPWR net16 sky130_fd_sc_hd__buf_2
XTAP_TAPCELL_ROW_1_50 VGND VPWR sky130_fd_sc_hd__tapvpwrvgnd_1
X_140_ net35 net30 net7 VGND VGND VPWR VPWR _014_ sky130_fd_sc_hd__mux2_1
XPHY_EDGE_ROW_14_Right_14 VGND VGND VPWR VPWR sky130_fd_sc_hd__decap_3
XFILLER_21_15 VGND VGND VPWR VPWR sky130_fd_sc_hd__fill_1
XTAP_TAPCELL_ROW_11_70 VGND VPWR sky130_fd_sc_hd__tapvpwrvgnd_1
X_123_ _052_ _053_ _054_ _071_ _077_ VGND VGND VPWR VPWR _043_ sky130_fd_sc_hd__o311a_1
X_106_ net10 rng_rd.ram_1\[2\] VGND VGND VPWR VPWR _075_ sky130_fd_sc_hd__or2_1
XFILLER_7_122 VGND VGND VPWR VPWR sky130_fd_sc_hd__fill_2
XPHY_EDGE_ROW_4_Right_4 VGND VGND VPWR VPWR sky130_fd_sc_hd__decap_3
XFILLER_5_94 VGND VGND VPWR VPWR sky130_fd_sc_hd__fill_4
XTAP_TAPCELL_ROW_1_51 VGND VPWR sky130_fd_sc_hd__tapvpwrvgnd_1
XFILLER_4_3 VGND VGND VPWR VPWR sky130_fd_sc_hd__fill_8
XTAP_TAPCELL_ROW_11_71 VGND VPWR sky130_fd_sc_hd__tapvpwrvgnd_1
X_122_ _039_ _040_ _041_ _038_ VGND VGND VPWR VPWR _042_ sky130_fd_sc_hd__a211o_1
XFILLER_11_93 VGND VGND VPWR VPWR sky130_fd_sc_hd__fill_1
XTAP_TAPCELL_ROW_22_92 VGND VPWR sky130_fd_sc_hd__tapvpwrvgnd_1
X_105_ net12 rng_rd.ram_1\[0\] VGND VGND VPWR VPWR _074_ sky130_fd_sc_hd__nand2_1
XFILLER_22_81 VGND VGND VPWR VPWR sky130_fd_sc_hd__fill_2
XFILLER_8_72 VPWR VGND VPWR VGND sky130_ef_sc_hd__decap_40_12
XPHY_EDGE_ROW_14_Left_37 VGND VGND VPWR VPWR sky130_fd_sc_hd__decap_3
XFILLER_6_7 VGND VGND VPWR VPWR sky130_fd_sc_hd__fill_2
XPHY_EDGE_ROW_17_Left_40 VGND VGND VPWR VPWR sky130_fd_sc_hd__decap_3
XPHY_EDGE_ROW_2_Left_25 VGND VGND VPWR VPWR sky130_fd_sc_hd__decap_3
XFILLER_10_29 VGND VGND VPWR VPWR sky130_fd_sc_hd__fill_4
XFILLER_2_63 VGND VGND VPWR VPWR sky130_fd_sc_hd__fill_1
X_121_ net10 rng_rd.ram_3\[2\] VGND VGND VPWR VPWR _041_ sky130_fd_sc_hd__xor2_1
XFILLER_21_109 VGND VGND VPWR VPWR sky130_fd_sc_hd__fill_2
XTAP_TAPCELL_ROW_7_62 VGND VPWR sky130_fd_sc_hd__tapvpwrvgnd_1
XTAP_TAPCELL_ROW_22_93 VGND VPWR sky130_fd_sc_hd__tapvpwrvgnd_1
XFILLER_7_102 VGND VGND VPWR VPWR sky130_fd_sc_hd__fill_8
XFILLER_7_124 VGND VGND VPWR VPWR sky130_fd_sc_hd__fill_1
X_104_ net12 rng_rd.ram_1\[0\] VGND VGND VPWR VPWR _073_ sky130_fd_sc_hd__or2_1
XTAP_TAPCELL_ROW_17_82 VGND VPWR sky130_fd_sc_hd__tapvpwrvgnd_1
XFILLER_12_3 VPWR VGND VPWR VGND sky130_ef_sc_hd__decap_40_12
XFILLER_5_41 VGND VGND VPWR VPWR sky130_fd_sc_hd__fill_4
XPHY_EDGE_ROW_10_Right_10 VGND VGND VPWR VPWR sky130_fd_sc_hd__decap_3
X_120_ rng_rd.cache\[1\] rng_rd.ram_3\[1\] VGND VGND VPWR VPWR _040_ sky130_fd_sc_hd__or2_1
XFILLER_11_40 VPWR VGND VPWR VGND sky130_ef_sc_hd__decap_40_12
XTAP_TAPCELL_ROW_7_63 VGND VPWR sky130_fd_sc_hd__tapvpwrvgnd_1
XTAP_TAPCELL_ROW_22_94 VGND VPWR sky130_fd_sc_hd__tapvpwrvgnd_1
XFILLER_20_121 VGND VGND VPWR VPWR sky130_fd_sc_hd__fill_4
XFILLER_22_83 VGND VGND VPWR VPWR sky130_fd_sc_hd__fill_1
X_103_ net11 rng_rd.ram_1\[1\] VGND VGND VPWR VPWR _072_ sky130_fd_sc_hd__xor2_1
XTAP_TAPCELL_ROW_17_83 VGND VPWR sky130_fd_sc_hd__tapvpwrvgnd_1
Xhold1 rng_rd.wr_ff1 VGND VGND VPWR VPWR net17 sky130_fd_sc_hd__dlygate4sd3_1
XPHY_EDGE_ROW_8_Right_8 VGND VGND VPWR VPWR sky130_fd_sc_hd__decap_3
XFILLER_1_109 VGND VGND VPWR VPWR sky130_fd_sc_hd__fill_2
XFILLER_6_9 VGND VGND VPWR VPWR sky130_fd_sc_hd__fill_1
X_196_ clknet_2_3__leaf_clk_i _001_ net16 VGND VGND VPWR VPWR rng_rd.wr_pulse sky130_fd_sc_hd__dfrtp_1
XFILLER_2_3 VGND VGND VPWR VPWR sky130_fd_sc_hd__fill_4
X_179_ clknet_2_0__leaf_clk_i _018_ net13 VGND VGND VPWR VPWR rng_rd.ram_2\[1\] sky130_fd_sc_hd__dfrtp_1
XFILLER_11_52 VGND VGND VPWR VPWR sky130_fd_sc_hd__fill_4
XTAP_TAPCELL_ROW_22_95 VGND VPWR sky130_fd_sc_hd__tapvpwrvgnd_1
X_102_ _066_ _067_ _069_ _070_ _068_ VGND VGND VPWR VPWR _071_ sky130_fd_sc_hd__a221o_1
XFILLER_11_122 VGND VGND VPWR VPWR sky130_fd_sc_hd__fill_2
XFILLER_8_42 VGND VGND VPWR VPWR sky130_fd_sc_hd__fill_2
Xhold2 rng_rd.wr_ff2 VGND VGND VPWR VPWR net18 sky130_fd_sc_hd__dlygate4sd3_1
XFILLER_5_98 VGND VGND VPWR VPWR sky130_fd_sc_hd__fill_2
X_195_ clknet_2_1__leaf_clk_i net37 net14 VGND VGND VPWR VPWR rng_rd.ram_6\[2\] sky130_fd_sc_hd__dfrtp_1
XPHY_EDGE_ROW_6_Left_29 VGND VGND VPWR VPWR sky130_fd_sc_hd__decap_3
X_178_ clknet_2_0__leaf_clk_i net31 net13 VGND VGND VPWR VPWR rng_rd.ram_2\[0\] sky130_fd_sc_hd__dfrtp_1
XFILLER_22_85 VPWR VGND VPWR VGND sky130_ef_sc_hd__decap_40_12
XFILLER_22_41 VPWR VGND VPWR VGND sky130_ef_sc_hd__decap_40_12
X_101_ net10 rng_rd.ram_4\[2\] VGND VGND VPWR VPWR _070_ sky130_fd_sc_hd__nand2_1
Xhold3 num_i_bar\[2\] VGND VGND VPWR VPWR net19 sky130_fd_sc_hd__dlygate4sd3_1
XPHY_EDGE_ROW_9_Left_32 VGND VGND VPWR VPWR sky130_fd_sc_hd__decap_3
XFILLER_0_111 VGND VGND VPWR VPWR sky130_fd_sc_hd__fill_1
XFILLER_5_55 VGND VGND VPWR VPWR sky130_fd_sc_hd__fill_1
XPHY_EDGE_ROW_22_Left_45 VGND VGND VPWR VPWR sky130_fd_sc_hd__decap_3
X_194_ clknet_2_3__leaf_clk_i net29 net16 VGND VGND VPWR VPWR rng_rd.ram_6\[1\] sky130_fd_sc_hd__dfrtp_1
X_177_ clknet_2_1__leaf_clk_i net34 net14 VGND VGND VPWR VPWR rng_rd.ram_3\[2\] sky130_fd_sc_hd__dfrtp_1
XFILLER_22_53 VGND VGND VPWR VPWR sky130_fd_sc_hd__fill_2
X_100_ net10 rng_rd.ram_4\[2\] VGND VGND VPWR VPWR _069_ sky130_fd_sc_hd__or2_1
XFILLER_11_124 VGND VGND VPWR VPWR sky130_fd_sc_hd__fill_1
XFILLER_22_97 VPWR VGND VPWR VGND sky130_ef_sc_hd__decap_40_12
Xhold4 rng_rd.wr_ff2_d VGND VGND VPWR VPWR net20 sky130_fd_sc_hd__dlygate4sd3_1
XTAP_TAPCELL_ROW_4_56 VGND VPWR sky130_fd_sc_hd__tapvpwrvgnd_1
XPHY_EDGE_ROW_17_Right_17 VGND VGND VPWR VPWR sky130_fd_sc_hd__decap_3
XFILLER_5_45 VGND VGND VPWR VPWR sky130_fd_sc_hd__fill_2
XFILLER_5_67 VGND VGND VPWR VPWR sky130_fd_sc_hd__fill_4
XTAP_TAPCELL_ROW_14_76 VGND VPWR sky130_fd_sc_hd__tapvpwrvgnd_1
X_193_ clknet_2_2__leaf_clk_i _029_ net15 VGND VGND VPWR VPWR rng_rd.ram_6\[0\] sky130_fd_sc_hd__dfrtp_1
XFILLER_11_99 VGND VGND VPWR VPWR sky130_fd_sc_hd__fill_4
X_176_ clknet_2_1__leaf_clk_i _015_ net14 VGND VGND VPWR VPWR rng_rd.ram_3\[1\] sky130_fd_sc_hd__dfrtp_1
XFILLER_11_103 VGND VGND VPWR VPWR sky130_fd_sc_hd__fill_1
XFILLER_0_3 VPWR VGND VPWR VGND sky130_ef_sc_hd__decap_40_12
XFILLER_8_12 VPWR VGND VPWR VGND sky130_ef_sc_hd__decap_40_12
X_159_ net47 net43 net9 VGND VGND VPWR VPWR _029_ sky130_fd_sc_hd__mux2_1
XTAP_TAPCELL_ROW_4_57 VGND VPWR sky130_fd_sc_hd__tapvpwrvgnd_1
Xhold5 rng_rd.ram_7\[1\] VGND VGND VPWR VPWR net21 sky130_fd_sc_hd__dlygate4sd3_1
XFILLER_0_113 VPWR VGND VPWR VGND sky130_ef_sc_hd__decap_40_12
XFILLER_5_57 VGND VGND VPWR VPWR sky130_fd_sc_hd__fill_2
XTAP_TAPCELL_ROW_14_77 VGND VPWR sky130_fd_sc_hd__tapvpwrvgnd_1
XFILLER_18_109 VPWR VGND VPWR VGND sky130_ef_sc_hd__decap_40_12
X_192_ clknet_2_2__leaf_clk_i _000_ net15 VGND VGND VPWR VPWR req_num_again sky130_fd_sc_hd__dfrtp_1
XFILLER_2_7 VGND VGND VPWR VPWR sky130_fd_sc_hd__fill_1
XFILLER_11_89 VGND VGND VPWR VPWR sky130_fd_sc_hd__fill_4
X_175_ clknet_2_0__leaf_clk_i _014_ net13 VGND VGND VPWR VPWR rng_rd.ram_3\[0\] sky130_fd_sc_hd__dfrtp_1
XFILLER_14_123 VGND VGND VPWR VPWR sky130_fd_sc_hd__fill_2
XFILLER_22_55 VGND VGND VPWR VPWR sky130_fd_sc_hd__fill_1
X_158_ net19 _048_ VGND VGND VPWR VPWR _028_ sky130_fd_sc_hd__xor2_1
XFILLER_8_24 VGND VGND VPWR VPWR sky130_fd_sc_hd__fill_4
X_089_ rng_rd.cache\[2\] rng_rd.ram_7\[2\] VGND VGND VPWR VPWR _058_ sky130_fd_sc_hd__nand2_1
XFILLER_17_77 VPWR VGND VPWR VGND sky130_ef_sc_hd__decap_40_12
XFILLER_17_66 VGND VGND VPWR VPWR sky130_fd_sc_hd__fill_4
XFILLER_17_55 VGND VGND VPWR VPWR sky130_fd_sc_hd__fill_1
Xhold6 _006_ VGND VGND VPWR VPWR net22 sky130_fd_sc_hd__dlygate4sd3_1
XFILLER_3_111 VGND VGND VPWR VPWR sky130_fd_sc_hd__fill_1
XPHY_EDGE_ROW_3_Right_3 VGND VGND VPWR VPWR sky130_fd_sc_hd__decap_3
XFILLER_5_47 VGND VGND VPWR VPWR sky130_fd_sc_hd__fill_1
XFILLER_14_23 VGND VGND VPWR VPWR sky130_fd_sc_hd__fill_4
X_191_ clknet_2_2__leaf_clk_i _028_ net16 VGND VGND VPWR VPWR num_i_bar\[2\] sky130_fd_sc_hd__dfrtp_1
XFILLER_2_59 VGND VGND VPWR VPWR sky130_fd_sc_hd__fill_4
XFILLER_11_57 VGND VGND VPWR VPWR sky130_fd_sc_hd__fill_1
X_174_ clknet_2_1__leaf_clk_i _013_ net14 VGND VGND VPWR VPWR rng_rd.ram_4\[2\] sky130_fd_sc_hd__dfrtp_1
XFILLER_14_102 VGND VGND VPWR VPWR sky130_fd_sc_hd__fill_1
X_157_ _048_ _049_ VGND VGND VPWR VPWR _027_ sky130_fd_sc_hd__nor2_1
XFILLER_19_3 VGND VGND VPWR VPWR sky130_fd_sc_hd__fill_1
X_088_ net12 rng_rd.ram_7\[0\] VGND VGND VPWR VPWR _057_ sky130_fd_sc_hd__xor2_1
Xhold7 rng_rd.ram_7\[2\] VGND VGND VPWR VPWR net23 sky130_fd_sc_hd__dlygate4sd3_1
XFILLER_0_81 VGND VGND VPWR VPWR sky130_fd_sc_hd__fill_2
XPHY_EDGE_ROW_13_Left_36 VGND VGND VPWR VPWR sky130_fd_sc_hd__decap_3
XPHY_EDGE_ROW_22_Right_22 VGND VGND VPWR VPWR sky130_fd_sc_hd__decap_3
XFILLER_10_7 VGND VGND VPWR VPWR sky130_fd_sc_hd__fill_1
XPHY_EDGE_ROW_13_Right_13 VGND VGND VPWR VPWR sky130_fd_sc_hd__decap_3
X_190_ clknet_2_2__leaf_clk_i _027_ net16 VGND VGND VPWR VPWR num_i_bar\[1\] sky130_fd_sc_hd__dfrtp_1
XFILLER_17_111 VGND VGND VPWR VPWR sky130_fd_sc_hd__fill_1
Xclkbuf_2_1__f_clk_i clknet_0_clk_i VGND VGND VPWR VPWR clknet_2_1__leaf_clk_i sky130_fd_sc_hd__clkbuf_16
X_173_ clknet_2_1__leaf_clk_i _012_ net14 VGND VGND VPWR VPWR rng_rd.ram_4\[1\] sky130_fd_sc_hd__dfrtp_1
XPHY_EDGE_ROW_1_Left_24 VGND VGND VPWR VPWR sky130_fd_sc_hd__decap_3
XFILLER_22_57 VPWR VGND VPWR VGND sky130_ef_sc_hd__decap_40_12
X_156_ num_i_bar\[1\] _046_ VGND VGND VPWR VPWR _049_ sky130_fd_sc_hd__and2b_1
XFILLER_6_121 VGND VGND VPWR VPWR sky130_fd_sc_hd__fill_4
X_087_ net11 rng_rd.ram_7\[1\] VGND VGND VPWR VPWR _056_ sky130_fd_sc_hd__nand2_1
XFILLER_17_57 VGND VGND VPWR VPWR sky130_fd_sc_hd__fill_1
XFILLER_3_113 VPWR VGND VPWR VGND sky130_ef_sc_hd__decap_40_12
Xhold8 _007_ VGND VGND VPWR VPWR net24 sky130_fd_sc_hd__dlygate4sd3_1
X_139_ net40 net33 net8 VGND VGND VPWR VPWR _013_ sky130_fd_sc_hd__mux2_1
XFILLER_6_81 VGND VGND VPWR VPWR sky130_fd_sc_hd__fill_2
XFILLER_17_101 VGND VGND VPWR VPWR sky130_fd_sc_hd__fill_8
X_172_ clknet_2_1__leaf_clk_i _011_ net13 VGND VGND VPWR VPWR rng_rd.ram_4\[0\] sky130_fd_sc_hd__dfrtp_1
XFILLER_22_69 VPWR VGND VPWR VGND sky130_ef_sc_hd__decap_40_12
X_086_ net11 rng_rd.ram_7\[1\] VGND VGND VPWR VPWR _055_ sky130_fd_sc_hd__or2_1
X_155_ req_num_again net1 num_i_bar\[1\] num_i_bar\[0\] VGND VGND VPWR VPWR _048_
+ sky130_fd_sc_hd__o211a_1
Xhold9 rng_rd.ram_7\[0\] VGND VGND VPWR VPWR net25 sky130_fd_sc_hd__dlygate4sd3_1
XFILLER_17_47 VGND VGND VPWR VPWR sky130_fd_sc_hd__fill_8
X_138_ net49 net48 net8 VGND VGND VPWR VPWR _012_ sky130_fd_sc_hd__mux2_1
XFILLER_0_83 VGND VGND VPWR VPWR sky130_fd_sc_hd__fill_1
XPHY_EDGE_ROW_7_Right_7 VGND VGND VPWR VPWR sky130_fd_sc_hd__decap_3
XFILLER_6_60 VGND VGND VPWR VPWR sky130_fd_sc_hd__fill_1
XFILLER_17_113 VPWR VGND VPWR VGND sky130_ef_sc_hd__decap_40_12
XFILLER_2_29 VGND VGND VPWR VPWR sky130_fd_sc_hd__fill_2
X_171_ clknet_2_2__leaf_clk_i net3 net15 VGND VGND VPWR VPWR rng_rd.wr_ff1 sky130_fd_sc_hd__dfrtp_1
XFILLER_22_15 VPWR VGND VPWR VGND sky130_ef_sc_hd__decap_40_12
X_085_ net11 rng_rd.ram_6\[1\] VGND VGND VPWR VPWR _054_ sky130_fd_sc_hd__xor2_1
X_154_ _046_ _047_ VGND VGND VPWR VPWR _026_ sky130_fd_sc_hd__and2_1
X_137_ net39 net35 net7 VGND VGND VPWR VPWR _011_ sky130_fd_sc_hd__mux2_1
XFILLER_0_51 VGND VGND VPWR VPWR sky130_fd_sc_hd__fill_4
XFILLER_14_27 VGND VGND VPWR VPWR sky130_fd_sc_hd__fill_1
XFILLER_14_49 VGND VGND VPWR VPWR sky130_fd_sc_hd__fill_1
XFILLER_6_83 VGND VGND VPWR VPWR sky130_fd_sc_hd__fill_1
X_170_ clknet_2_1__leaf_clk_i _010_ net14 VGND VGND VPWR VPWR rng_rd.ram_5\[2\] sky130_fd_sc_hd__dfrtp_1
XFILLER_20_109 VPWR VGND VPWR VGND sky130_ef_sc_hd__decap_40_12
XFILLER_9_110 VGND VGND VPWR VPWR sky130_fd_sc_hd__fill_2
XFILLER_22_27 VGND VGND VPWR VPWR sky130_fd_sc_hd__fill_1
XPHY_EDGE_ROW_5_Left_28 VGND VGND VPWR VPWR sky130_fd_sc_hd__decap_3
XFILLER_8_29 VGND VGND VPWR VPWR sky130_fd_sc_hd__fill_1
X_084_ rng_rd.cache\[2\] rng_rd.ram_6\[2\] VGND VGND VPWR VPWR _053_ sky130_fd_sc_hd__xor2_1
X_153_ num_i_bar\[0\] req_num_again net1 VGND VGND VPWR VPWR _047_ sky130_fd_sc_hd__or3_1
X_136_ net46 net40 net8 VGND VGND VPWR VPWR _010_ sky130_fd_sc_hd__mux2_1
XFILLER_0_85 VPWR VGND VPWR VGND sky130_ef_sc_hd__decap_40_12
XFILLER_0_41 VGND VGND VPWR VPWR sky130_fd_sc_hd__fill_1
XPHY_EDGE_ROW_8_Left_31 VGND VGND VPWR VPWR sky130_fd_sc_hd__decap_3
X_119_ rng_rd.cache\[1\] rng_rd.ram_3\[1\] VGND VGND VPWR VPWR _039_ sky130_fd_sc_hd__nand2_1
XFILLER_20_82 VGND VGND VPWR VPWR sky130_fd_sc_hd__fill_2
XTAP_TAPCELL_ROW_2_52 VGND VPWR sky130_fd_sc_hd__tapvpwrvgnd_1
XPHY_EDGE_ROW_21_Left_44 VGND VGND VPWR VPWR sky130_fd_sc_hd__decap_3
XTAP_TAPCELL_ROW_12_72 VGND VPWR sky130_fd_sc_hd__tapvpwrvgnd_1
X_083_ net12 rng_rd.ram_6\[0\] VGND VGND VPWR VPWR _052_ sky130_fd_sc_hd__xor2_1
XFILLER_12_83 VGND VGND VPWR VPWR sky130_fd_sc_hd__fill_1
X_152_ req_num_again net1 num_i_bar\[0\] VGND VGND VPWR VPWR _046_ sky130_fd_sc_hd__o21ai_1
XFILLER_0_97 VPWR VGND VPWR VGND sky130_ef_sc_hd__decap_40_12
X_135_ net44 rng_rd.ram_4\[1\] net8 VGND VGND VPWR VPWR _009_ sky130_fd_sc_hd__mux2_1
XFILLER_9_84 VGND VGND VPWR VPWR sky130_fd_sc_hd__fill_2
XFILLER_0_109 VGND VGND VPWR VPWR sky130_fd_sc_hd__fill_2
X_118_ rng_rd.cache\[0\] rng_rd.ram_3\[0\] VGND VGND VPWR VPWR _038_ sky130_fd_sc_hd__xor2_1
XFILLER_22_3 VPWR VGND VPWR VGND sky130_ef_sc_hd__decap_40_12
XTAP_TAPCELL_ROW_2_53 VGND VPWR sky130_fd_sc_hd__tapvpwrvgnd_1
XFILLER_22_29 VPWR VGND VPWR VGND sky130_ef_sc_hd__decap_40_12
X_151_ net6 net10 net7 VGND VGND VPWR VPWR _025_ sky130_fd_sc_hd__mux2_1
X_082_ net10 VGND VGND VPWR VPWR _051_ sky130_fd_sc_hd__inv_2
XTAP_TAPCELL_ROW_12_73 VGND VPWR sky130_fd_sc_hd__tapvpwrvgnd_1
XFILLER_3_107 VGND VGND VPWR VPWR sky130_fd_sc_hd__fill_4
XFILLER_0_65 VPWR VGND VPWR VGND sky130_ef_sc_hd__decap_40_12
X_134_ net43 net39 net9 VGND VGND VPWR VPWR _008_ sky130_fd_sc_hd__mux2_1
XFILLER_18_72 VPWR VGND VPWR VGND sky130_ef_sc_hd__decap_40_12
X_117_ net5 _050_ net6 _051_ _036_ VGND VGND VPWR VPWR _037_ sky130_fd_sc_hd__o221a_1
XFILLER_15_3 VPWR VGND VPWR VGND sky130_ef_sc_hd__decap_40_12
XFILLER_6_53 VGND VGND VPWR VPWR sky130_fd_sc_hd__fill_2
XFILLER_6_97 VGND VGND VPWR VPWR sky130_fd_sc_hd__fill_4
Xoutput4 net4 VGND VGND VPWR VPWR num_to_send_o[0] sky130_fd_sc_hd__buf_2
XFILLER_9_113 VGND VGND VPWR VPWR sky130_fd_sc_hd__fill_4
X_150_ net55 net11 net7 VGND VGND VPWR VPWR _024_ sky130_fd_sc_hd__mux2_1
X_081_ net11 VGND VGND VPWR VPWR _050_ sky130_fd_sc_hd__inv_2
XFILLER_10_101 VGND VGND VPWR VPWR sky130_fd_sc_hd__fill_2
XFILLER_10_123 VGND VGND VPWR VPWR sky130_fd_sc_hd__fill_2
XFILLER_12_85 VGND VGND VPWR VPWR sky130_fd_sc_hd__fill_2
XTAP_TAPCELL_ROW_8_64 VGND VPWR sky130_fd_sc_hd__tapvpwrvgnd_1
XPHY_EDGE_ROW_16_Right_16 VGND VGND VPWR VPWR sky130_fd_sc_hd__decap_3
X_133_ net23 rng_rd.ram_6\[2\] net9 VGND VGND VPWR VPWR _007_ sky130_fd_sc_hd__mux2_1
XFILLER_0_77 VGND VGND VPWR VPWR sky130_fd_sc_hd__fill_4
XFILLER_0_55 VGND VGND VPWR VPWR sky130_fd_sc_hd__fill_1
XFILLER_9_86 VGND VGND VPWR VPWR sky130_fd_sc_hd__fill_1
XFILLER_18_51 VGND VGND VPWR VPWR sky130_fd_sc_hd__fill_1
XTAP_TAPCELL_ROW_18_84 VGND VPWR sky130_fd_sc_hd__tapvpwrvgnd_1
X_116_ net5 _050_ net6 _051_ _035_ VGND VGND VPWR VPWR _036_ sky130_fd_sc_hd__a221oi_1
XPHY_EDGE_ROW_2_Right_2 VGND VGND VPWR VPWR sky130_fd_sc_hd__decap_3
XFILLER_20_85 VPWR VGND VPWR VGND sky130_ef_sc_hd__decap_40_12
XFILLER_20_74 VGND VGND VPWR VPWR sky130_fd_sc_hd__fill_8
XFILLER_20_63 VGND VGND VPWR VPWR sky130_fd_sc_hd__fill_2
XFILLER_20_41 VGND VGND VPWR VPWR sky130_fd_sc_hd__fill_2
Xoutput5 net5 VGND VGND VPWR VPWR num_to_send_o[1] sky130_fd_sc_hd__buf_2
XTAP_TAPCELL_ROW_8_65 VGND VPWR sky130_fd_sc_hd__tapvpwrvgnd_1
X_132_ net21 rng_rd.ram_6\[1\] net8 VGND VGND VPWR VPWR _006_ sky130_fd_sc_hd__mux2_1
XTAP_TAPCELL_ROW_18_85 VGND VPWR sky130_fd_sc_hd__tapvpwrvgnd_1
XFILLER_18_85 VPWR VGND VPWR VGND sky130_ef_sc_hd__decap_40_12
X_115_ net4 net12 VGND VGND VPWR VPWR _035_ sky130_fd_sc_hd__xor2_1
XPHY_EDGE_ROW_12_Left_35 VGND VGND VPWR VPWR sky130_fd_sc_hd__decap_3
XFILLER_20_97 VPWR VGND VPWR VGND sky130_ef_sc_hd__decap_40_12
XFILLER_20_3 VGND VGND VPWR VPWR sky130_fd_sc_hd__fill_1
Xoutput6 net6 VGND VGND VPWR VPWR num_to_send_o[2] sky130_fd_sc_hd__buf_2
.ends
