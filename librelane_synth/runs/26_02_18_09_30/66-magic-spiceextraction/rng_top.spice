* NGSPICE file created from rng_top.ext - technology: sky130A

* Black-box entry subcircuit for sky130_fd_sc_hd__fill_1 abstract view
.subckt sky130_fd_sc_hd__fill_1 VGND VNB VPB VPWR
.ends

* Black-box entry subcircuit for sky130_fd_sc_hd__fill_2 abstract view
.subckt sky130_fd_sc_hd__fill_2 VGND VNB VPB VPWR
.ends

* Black-box entry subcircuit for sky130_fd_sc_hd__fill_8 abstract view
.subckt sky130_fd_sc_hd__fill_8 VGND VNB VPB VPWR
.ends

* Black-box entry subcircuit for sky130_ef_sc_hd__decap_40_12 abstract view
.subckt sky130_ef_sc_hd__decap_40_12 VPWR VGND VPB VNB
.ends

* Black-box entry subcircuit for sky130_fd_sc_hd__decap_3 abstract view
.subckt sky130_fd_sc_hd__decap_3 VGND VNB VPB VPWR
.ends

* Black-box entry subcircuit for sky130_fd_sc_hd__mux2_1 abstract view
.subckt sky130_fd_sc_hd__mux2_1 A0 A1 S VGND VNB VPB VPWR X
.ends

* Black-box entry subcircuit for sky130_fd_sc_hd__o211ai_1 abstract view
.subckt sky130_fd_sc_hd__o211ai_1 A1 A2 B1 C1 VGND VNB VPB VPWR Y
.ends

* Black-box entry subcircuit for sky130_fd_sc_hd__fill_4 abstract view
.subckt sky130_fd_sc_hd__fill_4 VGND VNB VPB VPWR
.ends

* Black-box entry subcircuit for sky130_fd_sc_hd__inv_2 abstract view
.subckt sky130_fd_sc_hd__inv_2 A VGND VNB VPB VPWR Y
.ends

* Black-box entry subcircuit for sky130_fd_sc_hd__tapvpwrvgnd_1 abstract view
.subckt sky130_fd_sc_hd__tapvpwrvgnd_1 VGND VPWR
.ends

* Black-box entry subcircuit for sky130_fd_sc_hd__clkbuf_4 abstract view
.subckt sky130_fd_sc_hd__clkbuf_4 A VGND VNB VPB VPWR X
.ends

* Black-box entry subcircuit for sky130_fd_sc_hd__dlygate4sd3_1 abstract view
.subckt sky130_fd_sc_hd__dlygate4sd3_1 A VGND VNB VPB VPWR X
.ends

* Black-box entry subcircuit for sky130_fd_sc_hd__xnor2_1 abstract view
.subckt sky130_fd_sc_hd__xnor2_1 A B VGND VNB VPB VPWR Y
.ends

* Black-box entry subcircuit for sky130_fd_sc_hd__dfrtp_1 abstract view
.subckt sky130_fd_sc_hd__dfrtp_1 CLK D RESET_B VGND VNB VPB VPWR Q
.ends

* Black-box entry subcircuit for sky130_fd_sc_hd__and3_1 abstract view
.subckt sky130_fd_sc_hd__and3_1 A B C VGND VNB VPB VPWR X
.ends

* Black-box entry subcircuit for sky130_fd_sc_hd__clkbuf_16 abstract view
.subckt sky130_fd_sc_hd__clkbuf_16 A VGND VNB VPB VPWR X
.ends

* Black-box entry subcircuit for sky130_fd_sc_hd__a21o_1 abstract view
.subckt sky130_fd_sc_hd__a21o_1 A1 A2 B1 VGND VNB VPB VPWR X
.ends

* Black-box entry subcircuit for sky130_fd_sc_hd__a211o_1 abstract view
.subckt sky130_fd_sc_hd__a211o_1 A1 A2 B1 C1 VGND VNB VPB VPWR X
.ends

* Black-box entry subcircuit for sky130_fd_sc_hd__bufinv_16 abstract view
.subckt sky130_fd_sc_hd__bufinv_16 A VGND VNB VPB VPWR Y
.ends

* Black-box entry subcircuit for sky130_fd_sc_hd__a2111oi_1 abstract view
.subckt sky130_fd_sc_hd__a2111oi_1 A1 A2 B1 C1 D1 VGND VNB VPB VPWR Y
.ends

* Black-box entry subcircuit for sky130_fd_sc_hd__clkinv_2 abstract view
.subckt sky130_fd_sc_hd__clkinv_2 A VGND VNB VPB VPWR Y
.ends

* Black-box entry subcircuit for sky130_fd_sc_hd__or2_1 abstract view
.subckt sky130_fd_sc_hd__or2_1 A B VGND VNB VPB VPWR X
.ends

* Black-box entry subcircuit for sky130_fd_sc_hd__o21ai_1 abstract view
.subckt sky130_fd_sc_hd__o21ai_1 A1 A2 B1 VGND VNB VPB VPWR Y
.ends

* Black-box entry subcircuit for sky130_fd_sc_hd__nand2_1 abstract view
.subckt sky130_fd_sc_hd__nand2_1 A B VGND VNB VPB VPWR Y
.ends

* Black-box entry subcircuit for sky130_fd_sc_hd__a311o_1 abstract view
.subckt sky130_fd_sc_hd__a311o_1 A1 A2 A3 B1 C1 VGND VNB VPB VPWR X
.ends

* Black-box entry subcircuit for sky130_fd_sc_hd__a21oi_1 abstract view
.subckt sky130_fd_sc_hd__a21oi_1 A1 A2 B1 VGND VNB VPB VPWR Y
.ends

* Black-box entry subcircuit for sky130_fd_sc_hd__dfrtp_4 abstract view
.subckt sky130_fd_sc_hd__dfrtp_4 CLK D RESET_B VGND VNB VPB VPWR Q
.ends

* Black-box entry subcircuit for sky130_fd_sc_hd__clkbuf_2 abstract view
.subckt sky130_fd_sc_hd__clkbuf_2 A VGND VNB VPB VPWR X
.ends

* Black-box entry subcircuit for sky130_fd_sc_hd__nor2_1 abstract view
.subckt sky130_fd_sc_hd__nor2_1 A B VGND VNB VPB VPWR Y
.ends

* Black-box entry subcircuit for sky130_fd_sc_hd__xor2_1 abstract view
.subckt sky130_fd_sc_hd__xor2_1 A B VGND VNB VPB VPWR X
.ends

* Black-box entry subcircuit for sky130_fd_sc_hd__buf_2 abstract view
.subckt sky130_fd_sc_hd__buf_2 A VGND VNB VPB VPWR X
.ends

* Black-box entry subcircuit for sky130_fd_sc_hd__clkbuf_1 abstract view
.subckt sky130_fd_sc_hd__clkbuf_1 A VGND VNB VPB VPWR X
.ends

* Black-box entry subcircuit for sky130_fd_sc_hd__a221o_1 abstract view
.subckt sky130_fd_sc_hd__a221o_1 A1 A2 B1 B2 C1 VGND VNB VPB VPWR X
.ends

* Black-box entry subcircuit for sky130_fd_sc_hd__o22ai_1 abstract view
.subckt sky130_fd_sc_hd__o22ai_1 A1 A2 B1 B2 VGND VNB VPB VPWR Y
.ends

* Black-box entry subcircuit for sky130_fd_sc_hd__a2bb2o_1 abstract view
.subckt sky130_fd_sc_hd__a2bb2o_1 A1_N A2_N B1 B2 VGND VNB VPB VPWR X
.ends

* Black-box entry subcircuit for sky130_fd_sc_hd__dfrtp_2 abstract view
.subckt sky130_fd_sc_hd__dfrtp_2 CLK D RESET_B VGND VNB VPB VPWR Q
.ends

* Black-box entry subcircuit for sky130_fd_sc_hd__or3b_1 abstract view
.subckt sky130_fd_sc_hd__or3b_1 A B C_N VGND VNB VPB VPWR X
.ends

* Black-box entry subcircuit for sky130_fd_sc_hd__and2_1 abstract view
.subckt sky130_fd_sc_hd__and2_1 A B VGND VNB VPB VPWR X
.ends

* Black-box entry subcircuit for sky130_fd_sc_hd__o22a_1 abstract view
.subckt sky130_fd_sc_hd__o22a_1 A1 A2 B1 B2 VGND VNB VPB VPWR X
.ends

* Black-box entry subcircuit for sky130_fd_sc_hd__a31o_1 abstract view
.subckt sky130_fd_sc_hd__a31o_1 A1 A2 A3 B1 VGND VNB VPB VPWR X
.ends

* Black-box entry subcircuit for sky130_fd_sc_hd__o21a_1 abstract view
.subckt sky130_fd_sc_hd__o21a_1 A1 A2 B1 VGND VNB VPB VPWR X
.ends

* Black-box entry subcircuit for sky130_fd_sc_hd__o221a_1 abstract view
.subckt sky130_fd_sc_hd__o221a_1 A1 A2 B1 B2 C1 VGND VNB VPB VPWR X
.ends

* Black-box entry subcircuit for sky130_fd_sc_hd__and2b_1 abstract view
.subckt sky130_fd_sc_hd__and2b_1 A_N B VGND VNB VPB VPWR X
.ends

* Black-box entry subcircuit for sky130_fd_sc_hd__a31oi_1 abstract view
.subckt sky130_fd_sc_hd__a31oi_1 A1 A2 A3 B1 VGND VNB VPB VPWR Y
.ends

* Black-box entry subcircuit for sky130_fd_sc_hd__and4_1 abstract view
.subckt sky130_fd_sc_hd__and4_1 A B C D VGND VNB VPB VPWR X
.ends

* Black-box entry subcircuit for sky130_fd_sc_hd__or2_2 abstract view
.subckt sky130_fd_sc_hd__or2_2 A B VGND VNB VPB VPWR X
.ends

.subckt rng_top VGND VPWR clk_i num_to_send_o[0] num_to_send_o[1] num_to_send_o[2]
+ req_num_i rst_i wr_i
XFILLER_22_111 VGND VGND VPWR VPWR sky130_fd_sc_hd__fill_1
XFILLER_13_155 VGND VGND VPWR VPWR sky130_fd_sc_hd__fill_2
XFILLER_9_104 VGND VGND VPWR VPWR sky130_fd_sc_hd__fill_8
XFILLER_9_137 VPWR VGND VPWR VGND sky130_ef_sc_hd__decap_40_12
XPHY_EDGE_ROW_0_Left_23 VGND VGND VPWR VPWR sky130_fd_sc_hd__decap_3
X_200_ net52 net50 net8 VGND VGND VPWR VPWR _017_ sky130_fd_sc_hd__mux2_1
X_131_ net11 rng_rd.mem\[5\]\[0\] rng_rd.vld\[5\] _046_ VGND VGND VPWR VPWR _047_
+ sky130_fd_sc_hd__o211ai_1
XFILLER_0_57 VGND VGND VPWR VPWR sky130_fd_sc_hd__fill_8
XFILLER_0_24 VGND VGND VPWR VPWR sky130_fd_sc_hd__fill_4
X_114_ rng_dp.inst.next_num_o\[0\] VGND VGND VPWR VPWR _103_ sky130_fd_sc_hd__inv_2
XTAP_TAPCELL_ROW_20_98 VGND VPWR sky130_fd_sc_hd__tapvpwrvgnd_1
Xfanout7 net10 VGND VGND VPWR VPWR net7 sky130_fd_sc_hd__clkbuf_4
Xhold30 _011_ VGND VGND VPWR VPWR net49 sky130_fd_sc_hd__dlygate4sd3_1
Xhold41 _019_ VGND VGND VPWR VPWR net60 sky130_fd_sc_hd__dlygate4sd3_1
XFILLER_13_3 VGND VGND VPWR VPWR sky130_fd_sc_hd__fill_8
XTAP_TAPCELL_ROW_15_87 VGND VPWR sky130_fd_sc_hd__tapvpwrvgnd_1
XFILLER_16_153 VGND VGND VPWR VPWR sky130_fd_sc_hd__fill_4
XFILLER_9_149 VGND VGND VPWR VPWR sky130_fd_sc_hd__fill_8
XFILLER_10_137 VGND VGND VPWR VPWR sky130_fd_sc_hd__fill_2
XPHY_EDGE_ROW_21_Right_21 VGND VGND VPWR VPWR sky130_fd_sc_hd__decap_3
X_130_ num_i_bar\[1\] rng_rd.mem\[5\]\[1\] VGND VGND VPWR VPWR _046_ sky130_fd_sc_hd__xnor2_1
XPHY_EDGE_ROW_12_Right_12 VGND VGND VPWR VPWR sky130_fd_sc_hd__decap_3
X_259_ clknet_2_0__leaf_clk_i _031_ net14 VGND VGND VPWR VPWR rng_rd.vld\[1\] sky130_fd_sc_hd__dfrtp_1
XFILLER_2_155 VGND VGND VPWR VPWR sky130_fd_sc_hd__fill_2
X_113_ rng_dp.inst.next_num_o\[2\] VGND VGND VPWR VPWR _102_ sky130_fd_sc_hd__inv_2
Xfanout8 net10 VGND VGND VPWR VPWR net8 sky130_fd_sc_hd__clkbuf_4
Xhold42 rng_rd.mem\[5\]\[2\] VGND VGND VPWR VPWR net61 sky130_fd_sc_hd__dlygate4sd3_1
XTAP_TAPCELL_ROW_20_99 VGND VPWR sky130_fd_sc_hd__tapvpwrvgnd_1
XFILLER_20_33 VGND VGND VPWR VPWR sky130_fd_sc_hd__fill_2
Xhold31 rng_rd.mem\[3\]\[2\] VGND VGND VPWR VPWR net50 sky130_fd_sc_hd__dlygate4sd3_1
Xhold20 rng_rd.vld\[3\] VGND VGND VPWR VPWR net39 sky130_fd_sc_hd__dlygate4sd3_1
XFILLER_19_140 VPWR VGND VPWR VGND sky130_ef_sc_hd__decap_40_12
XFILLER_15_55 VGND VGND VPWR VPWR sky130_fd_sc_hd__fill_1
XPHY_EDGE_ROW_6_Right_6 VGND VGND VPWR VPWR sky130_fd_sc_hd__decap_3
XFILLER_15_88 VGND VGND VPWR VPWR sky130_fd_sc_hd__fill_4
XFILLER_22_113 VPWR VGND VPWR VGND sky130_ef_sc_hd__decap_40_12
XTAP_TAPCELL_ROW_20_100 VGND VPWR sky130_fd_sc_hd__tapvpwrvgnd_1
XTAP_TAPCELL_ROW_12_78 VGND VPWR sky130_fd_sc_hd__tapvpwrvgnd_1
XTAP_TAPCELL_ROW_8_68 VGND VPWR sky130_fd_sc_hd__tapvpwrvgnd_1
XFILLER_3_3 VGND VGND VPWR VPWR sky130_fd_sc_hd__fill_1
XFILLER_0_37 VPWR VGND VPWR VGND sky130_ef_sc_hd__decap_40_12
X_258_ clknet_2_0__leaf_clk_i _030_ net14 VGND VGND VPWR VPWR rng_rd.vld\[0\] sky130_fd_sc_hd__dfrtp_1
X_189_ rng_dp.seed_sel_i\[1\] rng_dp.seed_sel_i\[0\] _078_ VGND VGND VPWR VPWR _097_
+ sky130_fd_sc_hd__and3_1
XFILLER_9_57 VGND VGND VPWR VPWR sky130_fd_sc_hd__fill_1
Xfanout9 net10 VGND VGND VPWR VPWR net9 sky130_fd_sc_hd__clkbuf_4
Xclkbuf_2_0__f_clk_i clknet_0_clk_i VGND VGND VPWR VPWR clknet_2_0__leaf_clk_i sky130_fd_sc_hd__clkbuf_16
Xhold10 rng_rd.vld\[4\] VGND VGND VPWR VPWR net29 sky130_fd_sc_hd__dlygate4sd3_1
Xhold32 _020_ VGND VGND VPWR VPWR net51 sky130_fd_sc_hd__dlygate4sd3_1
XFILLER_20_6 VGND VGND VPWR VPWR sky130_fd_sc_hd__fill_2
XPHY_EDGE_ROW_16_Left_39 VGND VGND VPWR VPWR sky130_fd_sc_hd__decap_3
Xhold21 rng_rd.mem\[2\]\[0\] VGND VGND VPWR VPWR net40 sky130_fd_sc_hd__dlygate4sd3_1
Xhold43 rng_rd.mem\[2\]\[1\] VGND VGND VPWR VPWR net62 sky130_fd_sc_hd__dlygate4sd3_1
XFILLER_19_152 VGND VGND VPWR VPWR sky130_fd_sc_hd__fill_4
XFILLER_15_23 VGND VGND VPWR VPWR sky130_fd_sc_hd__fill_2
XFILLER_22_125 VPWR VGND VPWR VGND sky130_ef_sc_hd__decap_40_12
XFILLER_13_147 VGND VGND VPWR VPWR sky130_fd_sc_hd__fill_8
XPHY_EDGE_ROW_19_Left_42 VGND VGND VPWR VPWR sky130_fd_sc_hd__decap_3
XFILLER_10_139 VGND VGND VPWR VPWR sky130_fd_sc_hd__fill_1
XTAP_TAPCELL_ROW_12_79 VGND VPWR sky130_fd_sc_hd__tapvpwrvgnd_1
XTAP_TAPCELL_ROW_8_69 VGND VPWR sky130_fd_sc_hd__tapvpwrvgnd_1
XPHY_EDGE_ROW_4_Left_27 VGND VGND VPWR VPWR sky130_fd_sc_hd__decap_3
X_188_ rng_dp.inst.next_num_o\[2\] rng_dp.inst.next_num_o\[0\] rng_dp.inst.next_num_o\[1\]
+ VGND VGND VPWR VPWR _096_ sky130_fd_sc_hd__a21o_1
X_257_ clknet_2_0__leaf_clk_i _029_ net14 VGND VGND VPWR VPWR net6 sky130_fd_sc_hd__dfrtp_1
Xhold33 rng_rd.mem\[4\]\[2\] VGND VGND VPWR VPWR net52 sky130_fd_sc_hd__dlygate4sd3_1
Xhold11 _034_ VGND VGND VPWR VPWR net30 sky130_fd_sc_hd__dlygate4sd3_1
XPHY_EDGE_ROW_7_Left_30 VGND VGND VPWR VPWR sky130_fd_sc_hd__decap_3
Xhold22 _021_ VGND VGND VPWR VPWR net41 sky130_fd_sc_hd__dlygate4sd3_1
Xhold44 _022_ VGND VGND VPWR VPWR net63 sky130_fd_sc_hd__dlygate4sd3_1
XFILLER_15_57 VGND VGND VPWR VPWR sky130_fd_sc_hd__fill_4
XFILLER_11_3 VGND VGND VPWR VPWR sky130_fd_sc_hd__fill_1
XFILLER_22_137 VGND VGND VPWR VPWR sky130_fd_sc_hd__fill_2
XFILLER_8_141 VPWR VGND VPWR VGND sky130_ef_sc_hd__decap_40_12
XPHY_EDGE_ROW_20_Left_43 VGND VGND VPWR VPWR sky130_fd_sc_hd__decap_3
XFILLER_2_147 VGND VGND VPWR VPWR sky130_fd_sc_hd__fill_2
XFILLER_4_92 VGND VGND VPWR VPWR sky130_fd_sc_hd__fill_4
X_187_ rng_dp.seed_sel_i\[0\] _085_ _093_ _094_ VGND VGND VPWR VPWR _095_ sky130_fd_sc_hd__a211o_1
X_256_ clknet_2_0__leaf_clk_i _028_ net14 VGND VGND VPWR VPWR net5 sky130_fd_sc_hd__dfrtp_1
Xclkload0 clknet_2_1__leaf_clk_i VGND VGND VPWR VPWR clkload0/X sky130_fd_sc_hd__clkbuf_4
X_239_ clknet_2_1__leaf_clk_i _013_ net16 VGND VGND VPWR VPWR rng_rd.mem\[5\]\[1\]
+ sky130_fd_sc_hd__dfrtp_1
Xhold12 rng_rd.vld\[5\] VGND VGND VPWR VPWR net31 sky130_fd_sc_hd__dlygate4sd3_1
Xhold45 rng_rd.mem\[5\]\[0\] VGND VGND VPWR VPWR net64 sky130_fd_sc_hd__dlygate4sd3_1
Xhold34 rng_rd.mem\[1\]\[2\] VGND VGND VPWR VPWR net53 sky130_fd_sc_hd__dlygate4sd3_1
Xhold23 rng_rd.mem\[6\]\[0\] VGND VGND VPWR VPWR net42 sky130_fd_sc_hd__dlygate4sd3_1
XFILLER_15_25 VGND VGND VPWR VPWR sky130_fd_sc_hd__fill_1
XFILLER_21_90 VGND VGND VPWR VPWR sky130_fd_sc_hd__fill_2
XPHY_EDGE_ROW_19_Right_19 VGND VGND VPWR VPWR sky130_fd_sc_hd__decap_3
XTAP_TAPCELL_ROW_16_90 VGND VPWR sky130_fd_sc_hd__tapvpwrvgnd_1
XFILLER_8_153 VGND VGND VPWR VPWR sky130_fd_sc_hd__fill_4
XFILLER_12_26 VGND VGND VPWR VPWR sky130_fd_sc_hd__fill_2
XFILLER_5_156 VGND VGND VPWR VPWR sky130_fd_sc_hd__fill_1
X_255_ clknet_2_0__leaf_clk_i _027_ net15 VGND VGND VPWR VPWR net4 sky130_fd_sc_hd__dfrtp_1
X_186_ rng_dp.inst.next_num_o\[2\] rng_dp.seed_sel_i\[1\] _001_ VGND VGND VPWR VPWR
+ _094_ sky130_fd_sc_hd__and3_1
XFILLER_9_38 VGND VGND VPWR VPWR sky130_fd_sc_hd__fill_1
XTAP_TAPCELL_ROW_0_50 VGND VPWR sky130_fd_sc_hd__tapvpwrvgnd_1
Xclkload1 clknet_2_2__leaf_clk_i VGND VGND VPWR VPWR clkload1/Y sky130_fd_sc_hd__bufinv_16
X_169_ rng_dp.seed_sel_i\[1\] _077_ _078_ VGND VGND VPWR VPWR _079_ sky130_fd_sc_hd__and3_1
X_238_ clknet_2_3__leaf_clk_i _012_ net18 VGND VGND VPWR VPWR rng_rd.mem\[5\]\[0\]
+ sky130_fd_sc_hd__dfrtp_1
Xhold46 rng_rd.mem\[1\]\[0\] VGND VGND VPWR VPWR net65 sky130_fd_sc_hd__dlygate4sd3_1
Xhold13 num_i_bar\[2\] VGND VGND VPWR VPWR net32 sky130_fd_sc_hd__dlygate4sd3_1
Xhold24 _009_ VGND VGND VPWR VPWR net43 sky130_fd_sc_hd__dlygate4sd3_1
Xhold35 _026_ VGND VGND VPWR VPWR net54 sky130_fd_sc_hd__dlygate4sd3_1
XFILLER_19_111 VGND VGND VPWR VPWR sky130_fd_sc_hd__fill_1
XFILLER_15_15 VGND VGND VPWR VPWR sky130_fd_sc_hd__fill_8
XFILLER_16_136 VGND VGND VPWR VPWR sky130_fd_sc_hd__fill_4
XFILLER_22_139 VGND VGND VPWR VPWR sky130_fd_sc_hd__fill_1
XFILLER_10_109 VPWR VGND VPWR VGND sky130_ef_sc_hd__decap_40_12
Xclkbuf_2_3__f_clk_i clknet_0_clk_i VGND VGND VPWR VPWR clknet_2_3__leaf_clk_i sky130_fd_sc_hd__clkbuf_16
XFILLER_4_83 VGND VGND VPWR VPWR sky130_fd_sc_hd__fill_1
XFILLER_2_127 VGND VGND VPWR VPWR sky130_fd_sc_hd__fill_1
X_254_ clknet_2_0__leaf_clk_i net20 net14 VGND VGND VPWR VPWR rng_rd.wr_ff2 sky130_fd_sc_hd__dfrtp_1
X_185_ rng_dp.inst.next_num_o\[1\] _085_ _082_ rng_dp.seed_sel_i\[1\] rng_dp.seed_sel_i\[0\]
+ VGND VGND VPWR VPWR _093_ sky130_fd_sc_hd__a2111oi_1
XTAP_TAPCELL_ROW_13_81 VGND VPWR sky130_fd_sc_hd__tapvpwrvgnd_1
XTAP_TAPCELL_ROW_9_71 VGND VPWR sky130_fd_sc_hd__tapvpwrvgnd_1
Xclkload2 clknet_2_3__leaf_clk_i VGND VGND VPWR VPWR clkload2/Y sky130_fd_sc_hd__clkinv_2
X_237_ clknet_2_3__leaf_clk_i net49 net18 VGND VGND VPWR VPWR rng_rd.mem\[6\]\[2\]
+ sky130_fd_sc_hd__dfrtp_1
X_168_ rng_dp.inst.next_num_o\[2\] rng_dp.inst.next_num_o\[0\] VGND VGND VPWR VPWR
+ _078_ sky130_fd_sc_hd__or2_1
Xhold36 rng_rd.mem\[4\]\[1\] VGND VGND VPWR VPWR net55 sky130_fd_sc_hd__dlygate4sd3_1
Xhold14 rng_rd.vld\[0\] VGND VGND VPWR VPWR net33 sky130_fd_sc_hd__dlygate4sd3_1
Xhold47 rng_rd.mem\[1\]\[1\] VGND VGND VPWR VPWR net66 sky130_fd_sc_hd__dlygate4sd3_1
Xhold25 rng_rd.mem\[3\]\[0\] VGND VGND VPWR VPWR net44 sky130_fd_sc_hd__dlygate4sd3_1
XFILLER_19_156 VGND VGND VPWR VPWR sky130_fd_sc_hd__fill_1
XFILLER_16_115 VGND VGND VPWR VPWR sky130_fd_sc_hd__fill_1
XPHY_EDGE_ROW_1_Right_1 VGND VGND VPWR VPWR sky130_fd_sc_hd__decap_3
XFILLER_22_107 VGND VGND VPWR VPWR sky130_fd_sc_hd__fill_4
XFILLER_21_81 VGND VGND VPWR VPWR sky130_fd_sc_hd__fill_1
XFILLER_7_83 VGND VGND VPWR VPWR sky130_fd_sc_hd__fill_8
XFILLER_16_92 VGND VGND VPWR VPWR sky130_fd_sc_hd__fill_4
XFILLER_12_17 VGND VGND VPWR VPWR sky130_fd_sc_hd__fill_2
X_270_ clknet_2_0__leaf_clk_i _000_ net15 VGND VGND VPWR VPWR rng_rd.wr_pulse sky130_fd_sc_hd__dfrtp_1
XTAP_TAPCELL_ROW_13_82 VGND VPWR sky130_fd_sc_hd__tapvpwrvgnd_1
XFILLER_9_29 VGND VGND VPWR VPWR sky130_fd_sc_hd__fill_1
X_184_ _105_ _107_ _092_ VGND VGND VPWR VPWR _007_ sky130_fd_sc_hd__o21ai_1
XTAP_TAPCELL_ROW_9_72 VGND VPWR sky130_fd_sc_hd__tapvpwrvgnd_1
X_253_ clknet_2_1__leaf_clk_i net54 net14 VGND VGND VPWR VPWR rng_rd.mem\[1\]\[2\]
+ sky130_fd_sc_hd__dfrtp_1
X_236_ clknet_2_3__leaf_clk_i net47 net18 VGND VGND VPWR VPWR rng_rd.mem\[6\]\[1\]
+ sky130_fd_sc_hd__dfrtp_1
X_167_ _103_ rng_dp.inst.next_num_o\[1\] VGND VGND VPWR VPWR _077_ sky130_fd_sc_hd__nand2_1
XFILLER_1_41 VGND VGND VPWR VPWR sky130_fd_sc_hd__fill_4
Xhold15 rng_rd.vld\[6\] VGND VGND VPWR VPWR net34 sky130_fd_sc_hd__dlygate4sd3_1
Xhold37 _016_ VGND VGND VPWR VPWR net56 sky130_fd_sc_hd__dlygate4sd3_1
Xhold26 rng_rd.mem\[4\]\[0\] VGND VGND VPWR VPWR net45 sky130_fd_sc_hd__dlygate4sd3_1
Xhold48 net6 VGND VGND VPWR VPWR net67 sky130_fd_sc_hd__dlygate4sd3_1
X_219_ net34 net31 net9 VGND VGND VPWR VPWR _036_ sky130_fd_sc_hd__mux2_1
XPHY_EDGE_ROW_11_Left_34 VGND VGND VPWR VPWR sky130_fd_sc_hd__decap_3
XPHY_EDGE_ROW_15_Right_15 VGND VGND VPWR VPWR sky130_fd_sc_hd__decap_3
XFILLER_7_51 VGND VGND VPWR VPWR sky130_fd_sc_hd__fill_4
XFILLER_8_134 VGND VGND VPWR VPWR sky130_fd_sc_hd__fill_4
XFILLER_12_141 VPWR VGND VPWR VGND sky130_ef_sc_hd__decap_40_12
XFILLER_4_96 VGND VGND VPWR VPWR sky130_fd_sc_hd__fill_1
X_183_ _080_ _089_ _090_ _091_ _108_ VGND VGND VPWR VPWR _092_ sky130_fd_sc_hd__a311o_1
X_252_ clknet_2_0__leaf_clk_i _025_ net14 VGND VGND VPWR VPWR rng_rd.mem\[1\]\[1\]
+ sky130_fd_sc_hd__dfrtp_1
XFILLER_13_72 VGND VGND VPWR VPWR sky130_fd_sc_hd__fill_2
XFILLER_13_94 VGND VGND VPWR VPWR sky130_fd_sc_hd__fill_1
XFILLER_1_6 VPWR VGND VPWR VGND sky130_ef_sc_hd__decap_40_12
X_235_ clknet_2_3__leaf_clk_i net43 net18 VGND VGND VPWR VPWR rng_rd.mem\[6\]\[0\]
+ sky130_fd_sc_hd__dfrtp_1
XFILLER_20_29 VGND VGND VPWR VPWR sky130_fd_sc_hd__fill_4
X_166_ _074_ _075_ _073_ VGND VGND VPWR VPWR _076_ sky130_fd_sc_hd__a21oi_1
XFILLER_1_20 VGND VGND VPWR VPWR sky130_fd_sc_hd__fill_1
Xhold38 rng_rd.mem\[5\]\[1\] VGND VGND VPWR VPWR net57 sky130_fd_sc_hd__dlygate4sd3_1
Xhold27 rng_rd.mem\[6\]\[1\] VGND VGND VPWR VPWR net46 sky130_fd_sc_hd__dlygate4sd3_1
Xhold16 rng_rd.mem\[7\]\[0\] VGND VGND VPWR VPWR net35 sky130_fd_sc_hd__dlygate4sd3_1
Xhold49 num_i_bar\[0\] VGND VGND VPWR VPWR net68 sky130_fd_sc_hd__dlygate4sd3_1
XFILLER_10_40 VGND VGND VPWR VPWR sky130_fd_sc_hd__fill_1
XTAP_TAPCELL_ROW_10_73 VGND VPWR sky130_fd_sc_hd__tapvpwrvgnd_1
X_218_ net31 net29 net8 VGND VGND VPWR VPWR _035_ sky130_fd_sc_hd__mux2_1
X_149_ net12 rng_rd.mem\[7\]\[0\] _062_ _064_ VGND VGND VPWR VPWR _065_ sky130_fd_sc_hd__a211o_1
XTAP_TAPCELL_ROW_6_63 VGND VPWR sky130_fd_sc_hd__tapvpwrvgnd_1
XFILLER_16_106 VGND VGND VPWR VPWR sky130_fd_sc_hd__fill_1
XFILLER_12_153 VGND VGND VPWR VPWR sky130_fd_sc_hd__fill_4
XFILLER_4_31 VGND VGND VPWR VPWR sky130_fd_sc_hd__fill_1
X_251_ clknet_2_0__leaf_clk_i _024_ net15 VGND VGND VPWR VPWR rng_rd.mem\[1\]\[0\]
+ sky130_fd_sc_hd__dfrtp_1
X_182_ _077_ _083_ _080_ VGND VGND VPWR VPWR _091_ sky130_fd_sc_hd__a21oi_1
XFILLER_18_29 VGND VGND VPWR VPWR sky130_fd_sc_hd__fill_1
X_165_ rng_dp.inst.next_num_o\[2\] rng_dp.inst.next_num_o\[1\] _001_ rng_dp.seed_sel_i\[1\]
+ VGND VGND VPWR VPWR _075_ sky130_fd_sc_hd__a211o_1
X_234_ clknet_2_2__leaf_clk_i _002_ net17 VGND VGND VPWR VPWR rng_dp.seed_sel_i\[1\]
+ sky130_fd_sc_hd__dfrtp_4
Xhold28 _010_ VGND VGND VPWR VPWR net47 sky130_fd_sc_hd__dlygate4sd3_1
Xhold17 _003_ VGND VGND VPWR VPWR net36 sky130_fd_sc_hd__dlygate4sd3_1
XTAP_TAPCELL_ROW_10_74 VGND VPWR sky130_fd_sc_hd__tapvpwrvgnd_1
Xhold39 rng_rd.mem\[2\]\[2\] VGND VGND VPWR VPWR net58 sky130_fd_sc_hd__dlygate4sd3_1
X_217_ net29 rng_rd.vld\[3\] net8 VGND VGND VPWR VPWR _034_ sky130_fd_sc_hd__mux2_1
X_148_ net12 rng_rd.mem\[7\]\[0\] rng_rd.vld\[7\] _063_ VGND VGND VPWR VPWR _064_
+ sky130_fd_sc_hd__o211ai_1
XTAP_TAPCELL_ROW_6_64 VGND VPWR sky130_fd_sc_hd__tapvpwrvgnd_1
XFILLER_10_85 VPWR VGND VPWR VGND sky130_ef_sc_hd__decap_40_12
XFILLER_21_51 VGND VGND VPWR VPWR sky130_fd_sc_hd__fill_4
XFILLER_7_64 VGND VGND VPWR VPWR sky130_fd_sc_hd__fill_2
XFILLER_21_121 VPWR VGND VPWR VGND sky130_ef_sc_hd__decap_40_12
XPHY_EDGE_ROW_5_Right_5 VGND VGND VPWR VPWR sky130_fd_sc_hd__decap_3
XFILLER_16_40 VGND VGND VPWR VPWR sky130_fd_sc_hd__fill_1
XFILLER_12_132 VGND VGND VPWR VPWR sky130_fd_sc_hd__fill_8
X_181_ _102_ _077_ _073_ _001_ VGND VGND VPWR VPWR _090_ sky130_fd_sc_hd__a211o_1
X_250_ clknet_2_1__leaf_clk_i _023_ net16 VGND VGND VPWR VPWR rng_rd.mem\[2\]\[2\]
+ sky130_fd_sc_hd__dfrtp_1
XFILLER_1_153 VGND VGND VPWR VPWR sky130_fd_sc_hd__fill_4
X_233_ clknet_2_2__leaf_clk_i _001_ net17 VGND VGND VPWR VPWR rng_dp.seed_sel_i\[0\]
+ sky130_fd_sc_hd__dfrtp_4
XFILLER_1_77 VGND VGND VPWR VPWR sky130_fd_sc_hd__fill_2
X_164_ rng_dp.inst.next_num_o\[2\] _103_ rng_dp.seed_sel_i\[1\] rng_dp.seed_sel_i\[0\]
+ VGND VGND VPWR VPWR _074_ sky130_fd_sc_hd__a211o_1
Xhold29 rng_rd.mem\[6\]\[2\] VGND VGND VPWR VPWR net48 sky130_fd_sc_hd__dlygate4sd3_1
Xhold18 rng_rd.vld\[1\] VGND VGND VPWR VPWR net37 sky130_fd_sc_hd__dlygate4sd3_1
XTAP_TAPCELL_ROW_10_75 VGND VPWR sky130_fd_sc_hd__tapvpwrvgnd_1
XTAP_TAPCELL_ROW_6_65 VGND VPWR sky130_fd_sc_hd__tapvpwrvgnd_1
XFILLER_10_97 VPWR VGND VPWR VGND sky130_ef_sc_hd__decap_40_12
XFILLER_18_3 VGND VGND VPWR VPWR sky130_fd_sc_hd__fill_1
X_147_ num_i_bar\[1\] rng_rd.mem\[7\]\[1\] VGND VGND VPWR VPWR _063_ sky130_fd_sc_hd__xnor2_1
X_216_ net39 net38 net8 VGND VGND VPWR VPWR _033_ sky130_fd_sc_hd__mux2_1
XPHY_EDGE_ROW_15_Left_38 VGND VGND VPWR VPWR sky130_fd_sc_hd__decap_3
XFILLER_21_133 VPWR VGND VPWR VGND sky130_ef_sc_hd__decap_40_12
XFILLER_21_111 VGND VGND VPWR VPWR sky130_fd_sc_hd__fill_1
XPHY_EDGE_ROW_20_Right_20 VGND VGND VPWR VPWR sky130_fd_sc_hd__decap_3
XFILLER_16_96 VGND VGND VPWR VPWR sky130_fd_sc_hd__fill_1
XFILLER_16_85 VGND VGND VPWR VPWR sky130_fd_sc_hd__fill_1
XFILLER_8_126 VGND VGND VPWR VPWR sky130_fd_sc_hd__fill_1
XPHY_EDGE_ROW_11_Right_11 VGND VGND VPWR VPWR sky130_fd_sc_hd__decap_3
XPHY_EDGE_ROW_18_Left_41 VGND VGND VPWR VPWR sky130_fd_sc_hd__decap_3
Xfanout10 _072_ VGND VGND VPWR VPWR net10 sky130_fd_sc_hd__clkbuf_2
X_180_ _074_ _088_ _087_ VGND VGND VPWR VPWR _089_ sky130_fd_sc_hd__a21o_1
XPHY_EDGE_ROW_3_Left_26 VGND VGND VPWR VPWR sky130_fd_sc_hd__decap_3
X_163_ _103_ rng_dp.inst.next_num_o\[1\] VGND VGND VPWR VPWR _073_ sky130_fd_sc_hd__nor2_1
X_232_ clknet_2_2__leaf_clk_i _008_ net17 VGND VGND VPWR VPWR num_i_bar\[2\] sky130_fd_sc_hd__dfrtp_1
XFILLER_1_45 VGND VGND VPWR VPWR sky130_fd_sc_hd__fill_2
Xhold19 rng_rd.vld\[2\] VGND VGND VPWR VPWR net38 sky130_fd_sc_hd__dlygate4sd3_1
XFILLER_19_128 VPWR VGND VPWR VGND sky130_ef_sc_hd__decap_40_12
XFILLER_19_96 VGND VGND VPWR VPWR sky130_fd_sc_hd__fill_4
XTAP_TAPCELL_ROW_19_96 VGND VPWR sky130_fd_sc_hd__tapvpwrvgnd_1
X_146_ net13 rng_rd.mem\[7\]\[2\] VGND VGND VPWR VPWR _062_ sky130_fd_sc_hd__xor2_1
X_215_ net38 net37 net7 VGND VGND VPWR VPWR _032_ sky130_fd_sc_hd__mux2_1
XFILLER_7_11 VGND VGND VPWR VPWR sky130_fd_sc_hd__fill_2
XFILLER_7_22 VGND VGND VPWR VPWR sky130_fd_sc_hd__fill_1
XFILLER_7_55 VGND VGND VPWR VPWR sky130_fd_sc_hd__fill_1
XFILLER_21_145 VPWR VGND VPWR VGND sky130_ef_sc_hd__decap_40_12
X_129_ net13 rng_rd.mem\[5\]\[2\] VGND VGND VPWR VPWR _045_ sky130_fd_sc_hd__xor2_1
XFILLER_16_31 VGND VGND VPWR VPWR sky130_fd_sc_hd__fill_1
XTAP_TAPCELL_ROW_3_56 VGND VPWR sky130_fd_sc_hd__tapvpwrvgnd_1
XFILLER_8_138 VGND VGND VPWR VPWR sky130_fd_sc_hd__fill_2
XFILLER_4_67 VGND VGND VPWR VPWR sky130_fd_sc_hd__fill_2
Xfanout11 net12 VGND VGND VPWR VPWR net11 sky130_fd_sc_hd__buf_2
XFILLER_1_111 VGND VGND VPWR VPWR sky130_fd_sc_hd__fill_1
XTAP_TAPCELL_ROW_0_46 VGND VPWR sky130_fd_sc_hd__tapvpwrvgnd_1
XFILLER_8_3 VGND VGND VPWR VPWR sky130_fd_sc_hd__fill_4
Xclkbuf_0_clk_i clk_i VGND VGND VPWR VPWR clknet_0_clk_i sky130_fd_sc_hd__clkbuf_16
X_162_ net25 rng_rd.mem\[6\]\[2\] net10 VGND VGND VPWR VPWR _005_ sky130_fd_sc_hd__mux2_1
X_231_ clknet_2_2__leaf_clk_i _007_ net17 VGND VGND VPWR VPWR num_i_bar\[1\] sky130_fd_sc_hd__dfrtp_4
XTAP_TAPCELL_ROW_19_97 VGND VPWR sky130_fd_sc_hd__tapvpwrvgnd_1
Xinput1 req_num_i VGND VGND VPWR VPWR net1 sky130_fd_sc_hd__clkbuf_1
X_214_ net37 net33 net7 VGND VGND VPWR VPWR _031_ sky130_fd_sc_hd__mux2_1
X_145_ net4 net11 _059_ _060_ VGND VGND VPWR VPWR _061_ sky130_fd_sc_hd__a211o_1
XFILLER_21_65 VPWR VGND VPWR VGND sky130_ef_sc_hd__decap_40_12
XFILLER_15_121 VGND VGND VPWR VPWR sky130_fd_sc_hd__fill_1
X_128_ net11 rng_rd.mem\[2\]\[0\] _042_ _043_ VGND VGND VPWR VPWR _044_ sky130_fd_sc_hd__a211o_1
XFILLER_16_65 VPWR VGND VPWR VGND sky130_ef_sc_hd__decap_40_12
XFILLER_16_54 VGND VGND VPWR VPWR sky130_fd_sc_hd__fill_4
XTAP_TAPCELL_ROW_3_57 VGND VPWR sky130_fd_sc_hd__tapvpwrvgnd_1
XFILLER_7_150 VGND VGND VPWR VPWR sky130_fd_sc_hd__fill_4
XPHY_EDGE_ROW_9_Right_9 VGND VGND VPWR VPWR sky130_fd_sc_hd__decap_3
XFILLER_4_57 VGND VGND VPWR VPWR sky130_fd_sc_hd__fill_1
XTAP_TAPCELL_ROW_0_47 VGND VPWR sky130_fd_sc_hd__tapvpwrvgnd_1
Xfanout12 _104_ VGND VGND VPWR VPWR net12 sky130_fd_sc_hd__clkbuf_2
X_161_ net27 rng_rd.mem\[6\]\[1\] net9 VGND VGND VPWR VPWR _004_ sky130_fd_sc_hd__mux2_1
X_230_ clknet_2_2__leaf_clk_i _006_ net17 VGND VGND VPWR VPWR num_i_bar\[0\] sky130_fd_sc_hd__dfrtp_1
XFILLER_1_47 VGND VGND VPWR VPWR sky130_fd_sc_hd__fill_1
Xinput2 rst_i VGND VGND VPWR VPWR net2 sky130_fd_sc_hd__clkbuf_1
XFILLER_10_23 VGND VGND VPWR VPWR sky130_fd_sc_hd__fill_1
XFILLER_10_56 VGND VGND VPWR VPWR sky130_fd_sc_hd__fill_1
X_213_ net33 net7 VGND VGND VPWR VPWR _030_ sky130_fd_sc_hd__or2_1
X_144_ net5 _105_ _057_ _058_ _106_ VGND VGND VPWR VPWR _060_ sky130_fd_sc_hd__a221o_1
XFILLER_18_141 VPWR VGND VPWR VGND sky130_ef_sc_hd__decap_40_12
XFILLER_21_77 VGND VGND VPWR VPWR sky130_fd_sc_hd__fill_4
XFILLER_21_55 VGND VGND VPWR VPWR sky130_fd_sc_hd__fill_1
XFILLER_16_3 VPWR VGND VPWR VGND sky130_ef_sc_hd__decap_40_12
XFILLER_15_155 VGND VGND VPWR VPWR sky130_fd_sc_hd__fill_2
X_127_ _105_ rng_rd.mem\[2\]\[1\] rng_rd.vld\[2\] _041_ VGND VGND VPWR VPWR _043_
+ sky130_fd_sc_hd__o211ai_1
XTAP_TAPCELL_ROW_16_88 VGND VPWR sky130_fd_sc_hd__tapvpwrvgnd_1
XFILLER_8_118 VGND VGND VPWR VPWR sky130_fd_sc_hd__fill_8
XFILLER_4_69 VGND VGND VPWR VPWR sky130_fd_sc_hd__fill_1
Xfanout13 num_i_bar\[2\] VGND VGND VPWR VPWR net13 sky130_fd_sc_hd__clkbuf_4
XFILLER_1_113 VPWR VGND VPWR VGND sky130_ef_sc_hd__decap_40_12
XTAP_TAPCELL_ROW_0_48 VGND VPWR sky130_fd_sc_hd__tapvpwrvgnd_1
X_160_ net35 rng_rd.mem\[6\]\[0\] net9 VGND VGND VPWR VPWR _003_ sky130_fd_sc_hd__mux2_1
XPHY_EDGE_ROW_18_Right_18 VGND VGND VPWR VPWR sky130_fd_sc_hd__decap_3
Xinput3 wr_i VGND VGND VPWR VPWR net3 sky130_fd_sc_hd__clkbuf_1
XFILLER_19_109 VGND VGND VPWR VPWR sky130_fd_sc_hd__fill_2
XFILLER_19_44 VGND VGND VPWR VPWR sky130_fd_sc_hd__fill_2
X_143_ net4 net11 net5 _105_ VGND VGND VPWR VPWR _059_ sky130_fd_sc_hd__o22ai_1
X_212_ net67 net13 net7 VGND VGND VPWR VPWR _029_ sky130_fd_sc_hd__mux2_1
XFILLER_18_153 VGND VGND VPWR VPWR sky130_fd_sc_hd__fill_4
X_126_ net11 rng_rd.mem\[2\]\[0\] rng_rd.mem\[2\]\[1\] _105_ VGND VGND VPWR VPWR _042_
+ sky130_fd_sc_hd__a2bb2o_1
XTAP_TAPCELL_ROW_16_89 VGND VPWR sky130_fd_sc_hd__tapvpwrvgnd_1
XPHY_EDGE_ROW_0_Right_0 VGND VGND VPWR VPWR sky130_fd_sc_hd__decap_3
XFILLER_4_26 VGND VGND VPWR VPWR sky130_fd_sc_hd__fill_2
XFILLER_4_100 VGND VGND VPWR VPWR sky130_fd_sc_hd__fill_1
XFILLER_1_125 VGND VGND VPWR VPWR sky130_fd_sc_hd__fill_4
XTAP_TAPCELL_ROW_0_49 VGND VPWR sky130_fd_sc_hd__tapvpwrvgnd_1
XFILLER_1_103 VGND VGND VPWR VPWR sky130_fd_sc_hd__fill_8
Xfanout14 net19 VGND VGND VPWR VPWR net14 sky130_fd_sc_hd__clkbuf_4
XFILLER_6_3 VGND VGND VPWR VPWR sky130_fd_sc_hd__fill_4
X_211_ net5 num_i_bar\[1\] net7 VGND VGND VPWR VPWR _028_ sky130_fd_sc_hd__mux2_1
X_142_ net6 net13 VGND VGND VPWR VPWR _058_ sky130_fd_sc_hd__or2_1
XFILLER_10_36 VGND VGND VPWR VPWR sky130_fd_sc_hd__fill_4
XFILLER_15_135 VPWR VGND VPWR VGND sky130_ef_sc_hd__decap_40_12
X_125_ net13 rng_rd.mem\[2\]\[2\] VGND VGND VPWR VPWR _041_ sky130_fd_sc_hd__xnor2_1
XPHY_EDGE_ROW_10_Left_33 VGND VGND VPWR VPWR sky130_fd_sc_hd__decap_3
XFILLER_21_3 VPWR VGND VPWR VGND sky130_ef_sc_hd__decap_40_12
XFILLER_4_49 VGND VGND VPWR VPWR sky130_fd_sc_hd__fill_8
XFILLER_4_156 VGND VGND VPWR VPWR sky130_fd_sc_hd__fill_1
Xfanout15 net19 VGND VGND VPWR VPWR net15 sky130_fd_sc_hd__clkbuf_2
XFILLER_8_7 VGND VGND VPWR VPWR sky130_fd_sc_hd__fill_2
XFILLER_19_57 VGND VGND VPWR VPWR sky130_fd_sc_hd__fill_2
XFILLER_19_46 VGND VGND VPWR VPWR sky130_fd_sc_hd__fill_1
X_210_ net4 net68 net7 VGND VGND VPWR VPWR _027_ sky130_fd_sc_hd__mux2_1
X_141_ net6 net13 VGND VGND VPWR VPWR _057_ sky130_fd_sc_hd__nand2_1
XFILLER_21_25 VGND VGND VPWR VPWR sky130_fd_sc_hd__fill_4
X_124_ net11 rng_rd.mem\[4\]\[0\] _110_ _111_ VGND VGND VPWR VPWR _112_ sky130_fd_sc_hd__a211o_1
XFILLER_15_147 VGND VGND VPWR VPWR sky130_fd_sc_hd__fill_8
XFILLER_11_80 VPWR VGND VPWR VGND sky130_ef_sc_hd__decap_40_12
Xclkbuf_2_2__f_clk_i clknet_0_clk_i VGND VGND VPWR VPWR clknet_2_2__leaf_clk_i sky130_fd_sc_hd__clkbuf_16
XFILLER_7_154 VGND VGND VPWR VPWR sky130_fd_sc_hd__fill_2
XFILLER_14_3 VGND VGND VPWR VPWR sky130_fd_sc_hd__fill_1
Xfanout16 net19 VGND VGND VPWR VPWR net16 sky130_fd_sc_hd__clkbuf_4
XTAP_TAPCELL_ROW_4_60 VGND VPWR sky130_fd_sc_hd__tapvpwrvgnd_1
XFILLER_1_18 VGND VGND VPWR VPWR sky130_fd_sc_hd__fill_2
XFILLER_10_27 VGND VGND VPWR VPWR sky130_fd_sc_hd__fill_1
XPHY_EDGE_ROW_14_Right_14 VGND VGND VPWR VPWR sky130_fd_sc_hd__decap_3
X_140_ net12 rng_rd.mem\[6\]\[0\] _054_ _055_ VGND VGND VPWR VPWR _056_ sky130_fd_sc_hd__a211o_1
X_269_ clknet_2_2__leaf_clk_i _040_ net17 VGND VGND VPWR VPWR rng_dp.inst.next_num_o\[2\]
+ sky130_fd_sc_hd__dfrtp_2
XFILLER_21_15 VGND VGND VPWR VPWR sky130_fd_sc_hd__fill_1
X_123_ _105_ rng_rd.mem\[4\]\[1\] rng_rd.vld\[4\] _109_ VGND VGND VPWR VPWR _111_
+ sky130_fd_sc_hd__o211ai_1
XFILLER_11_92 VGND VGND VPWR VPWR sky130_fd_sc_hd__fill_2
XFILLER_16_26 VGND VGND VPWR VPWR sky130_fd_sc_hd__fill_2
XFILLER_16_15 VGND VGND VPWR VPWR sky130_fd_sc_hd__fill_4
XFILLER_7_111 VGND VGND VPWR VPWR sky130_fd_sc_hd__fill_1
XPHY_EDGE_ROW_4_Right_4 VGND VGND VPWR VPWR sky130_fd_sc_hd__decap_3
XFILLER_8_60 VGND VGND VPWR VPWR sky130_fd_sc_hd__fill_2
XFILLER_8_93 VGND VGND VPWR VPWR sky130_fd_sc_hd__fill_2
XTAP_TAPCELL_ROW_17_91 VGND VPWR sky130_fd_sc_hd__tapvpwrvgnd_1
XFILLER_4_29 VGND VGND VPWR VPWR sky130_fd_sc_hd__fill_2
XFILLER_17_91 VGND VGND VPWR VPWR sky130_fd_sc_hd__fill_1
Xfanout17 net19 VGND VGND VPWR VPWR net17 sky130_fd_sc_hd__clkbuf_4
XFILLER_8_9 VGND VGND VPWR VPWR sky130_fd_sc_hd__fill_1
XFILLER_5_83 VGND VGND VPWR VPWR sky130_fd_sc_hd__fill_1
XTAP_TAPCELL_ROW_1_51 VGND VPWR sky130_fd_sc_hd__tapvpwrvgnd_1
XFILLER_19_59 VGND VGND VPWR VPWR sky130_fd_sc_hd__fill_1
XFILLER_4_3 VGND VGND VPWR VPWR sky130_fd_sc_hd__fill_4
X_199_ net55 rng_rd.mem\[3\]\[1\] net8 VGND VGND VPWR VPWR _016_ sky130_fd_sc_hd__mux2_1
X_268_ clknet_2_2__leaf_clk_i _039_ net17 VGND VGND VPWR VPWR rng_dp.inst.next_num_o\[1\]
+ sky130_fd_sc_hd__dfrtp_4
XFILLER_2_73 VGND VGND VPWR VPWR sky130_fd_sc_hd__fill_1
X_122_ net11 rng_rd.mem\[4\]\[0\] rng_rd.mem\[4\]\[1\] _105_ VGND VGND VPWR VPWR _110_
+ sky130_fd_sc_hd__a2bb2o_1
XTAP_TAPCELL_ROW_22_103 VGND VPWR sky130_fd_sc_hd__tapvpwrvgnd_1
XFILLER_20_141 VPWR VGND VPWR VGND sky130_ef_sc_hd__decap_40_12
XFILLER_7_156 VGND VGND VPWR VPWR sky130_fd_sc_hd__fill_1
XFILLER_22_81 VGND VGND VPWR VPWR sky130_fd_sc_hd__fill_2
XFILLER_8_83 VGND VGND VPWR VPWR sky130_fd_sc_hd__fill_1
XPHY_EDGE_ROW_14_Left_37 VGND VGND VPWR VPWR sky130_fd_sc_hd__decap_3
XTAP_TAPCELL_ROW_17_92 VGND VPWR sky130_fd_sc_hd__tapvpwrvgnd_1
Xfanout18 net19 VGND VGND VPWR VPWR net18 sky130_fd_sc_hd__buf_2
XFILLER_1_129 VGND VGND VPWR VPWR sky130_fd_sc_hd__fill_1
XFILLER_13_28 VGND VGND VPWR VPWR sky130_fd_sc_hd__fill_1
XPHY_EDGE_ROW_17_Left_40 VGND VGND VPWR VPWR sky130_fd_sc_hd__decap_3
XFILLER_6_7 VGND VGND VPWR VPWR sky130_fd_sc_hd__fill_1
XTAP_TAPCELL_ROW_1_52 VGND VPWR sky130_fd_sc_hd__tapvpwrvgnd_1
XPHY_EDGE_ROW_2_Left_25 VGND VGND VPWR VPWR sky130_fd_sc_hd__decap_3
X_267_ clknet_2_2__leaf_clk_i _038_ net17 VGND VGND VPWR VPWR rng_dp.inst.next_num_o\[0\]
+ sky130_fd_sc_hd__dfrtp_2
X_198_ net45 net44 net9 VGND VGND VPWR VPWR _015_ sky130_fd_sc_hd__mux2_1
XFILLER_21_39 VGND VGND VPWR VPWR sky130_fd_sc_hd__fill_4
XFILLER_2_85 VGND VGND VPWR VPWR sky130_fd_sc_hd__fill_2
X_121_ net13 rng_rd.mem\[4\]\[2\] VGND VGND VPWR VPWR _109_ sky130_fd_sc_hd__xnor2_1
XFILLER_21_109 VGND VGND VPWR VPWR sky130_fd_sc_hd__fill_2
XTAP_TAPCELL_ROW_22_104 VGND VPWR sky130_fd_sc_hd__tapvpwrvgnd_1
XFILLER_20_153 VGND VGND VPWR VPWR sky130_fd_sc_hd__fill_4
XFILLER_22_93 VGND VGND VPWR VPWR sky130_fd_sc_hd__fill_4
XFILLER_8_62 VGND VGND VPWR VPWR sky130_fd_sc_hd__fill_1
Xfanout19 net2 VGND VGND VPWR VPWR net19 sky130_fd_sc_hd__clkbuf_2
XFILLER_12_3 VGND VGND VPWR VPWR sky130_fd_sc_hd__fill_4
XFILLER_0_141 VPWR VGND VPWR VGND sky130_ef_sc_hd__decap_40_12
XTAP_TAPCELL_ROW_14_83 VGND VPWR sky130_fd_sc_hd__tapvpwrvgnd_1
X_197_ net61 net52 net8 VGND VGND VPWR VPWR _014_ sky130_fd_sc_hd__mux2_1
XFILLER_18_126 VPWR VGND VPWR VGND sky130_ef_sc_hd__decap_40_12
X_266_ clknet_2_0__leaf_clk_i net21 net15 VGND VGND VPWR VPWR rng_rd.wr_ff2_d sky130_fd_sc_hd__dfrtp_1
XFILLER_21_29 VGND VGND VPWR VPWR sky130_fd_sc_hd__fill_1
XPHY_EDGE_ROW_10_Right_10 VGND VGND VPWR VPWR sky130_fd_sc_hd__decap_3
X_120_ _107_ VGND VGND VPWR VPWR _108_ sky130_fd_sc_hd__inv_2
X_249_ clknet_2_0__leaf_clk_i net63 net15 VGND VGND VPWR VPWR rng_rd.mem\[2\]\[1\]
+ sky130_fd_sc_hd__dfrtp_1
XTAP_TAPCELL_ROW_22_105 VGND VPWR sky130_fd_sc_hd__tapvpwrvgnd_1
XFILLER_20_121 VPWR VGND VPWR VGND sky130_ef_sc_hd__decap_40_12
XFILLER_16_29 VGND VGND VPWR VPWR sky130_fd_sc_hd__fill_2
XFILLER_22_83 VGND VGND VPWR VPWR sky130_fd_sc_hd__fill_1
XFILLER_7_125 VGND VGND VPWR VPWR sky130_fd_sc_hd__fill_2
XFILLER_11_121 VPWR VGND VPWR VGND sky130_ef_sc_hd__decap_40_12
Xhold1 rng_rd.wr_ff1 VGND VGND VPWR VPWR net20 sky130_fd_sc_hd__dlygate4sd3_1
XPHY_EDGE_ROW_8_Right_8 VGND VGND VPWR VPWR sky130_fd_sc_hd__decap_3
XFILLER_0_153 VGND VGND VPWR VPWR sky130_fd_sc_hd__fill_4
XTAP_TAPCELL_ROW_14_84 VGND VPWR sky130_fd_sc_hd__tapvpwrvgnd_1
XFILLER_18_138 VGND VGND VPWR VPWR sky130_fd_sc_hd__fill_2
X_196_ net57 net55 net9 VGND VGND VPWR VPWR _013_ sky130_fd_sc_hd__mux2_1
X_265_ clknet_2_3__leaf_clk_i net24 net18 VGND VGND VPWR VPWR rng_rd.vld\[7\] sky130_fd_sc_hd__dfrtp_1
XFILLER_14_141 VPWR VGND VPWR VGND sky130_ef_sc_hd__decap_40_12
XFILLER_2_3 VGND VGND VPWR VPWR sky130_fd_sc_hd__fill_1
X_179_ rng_dp.seed_sel_i\[0\] _082_ rng_dp.seed_sel_i\[1\] VGND VGND VPWR VPWR _088_
+ sky130_fd_sc_hd__or3b_1
X_248_ clknet_2_2__leaf_clk_i net41 net15 VGND VGND VPWR VPWR rng_rd.mem\[2\]\[0\]
+ sky130_fd_sc_hd__dfrtp_1
XTAP_TAPCELL_ROW_22_106 VGND VPWR sky130_fd_sc_hd__tapvpwrvgnd_1
XFILLER_20_133 VGND VGND VPWR VPWR sky130_fd_sc_hd__fill_4
XFILLER_11_111 VGND VGND VPWR VPWR sky130_fd_sc_hd__fill_1
XFILLER_11_133 VPWR VGND VPWR VGND sky130_ef_sc_hd__decap_40_12
Xhold2 rng_rd.wr_ff2 VGND VGND VPWR VPWR net21 sky130_fd_sc_hd__dlygate4sd3_1
XFILLER_5_21 VGND VGND VPWR VPWR sky130_fd_sc_hd__fill_2
XTAP_TAPCELL_ROW_14_85 VGND VPWR sky130_fd_sc_hd__tapvpwrvgnd_1
XFILLER_14_52 VGND VGND VPWR VPWR sky130_fd_sc_hd__fill_4
XFILLER_4_7 VGND VGND VPWR VPWR sky130_fd_sc_hd__fill_2
X_264_ clknet_2_3__leaf_clk_i _036_ net18 VGND VGND VPWR VPWR rng_rd.vld\[6\] sky130_fd_sc_hd__dfrtp_1
X_195_ net64 net45 net9 VGND VGND VPWR VPWR _012_ sky130_fd_sc_hd__mux2_1
XPHY_EDGE_ROW_6_Left_29 VGND VGND VPWR VPWR sky130_fd_sc_hd__decap_3
X_247_ clknet_2_1__leaf_clk_i net51 net16 VGND VGND VPWR VPWR rng_rd.mem\[3\]\[2\]
+ sky130_fd_sc_hd__dfrtp_1
XFILLER_14_153 VGND VGND VPWR VPWR sky130_fd_sc_hd__fill_4
XTAP_TAPCELL_ROW_22_107 VGND VPWR sky130_fd_sc_hd__tapvpwrvgnd_1
X_178_ _102_ rng_dp.inst.next_num_o\[1\] VGND VGND VPWR VPWR _087_ sky130_fd_sc_hd__and2_1
XFILLER_22_85 VGND VGND VPWR VPWR sky130_fd_sc_hd__fill_4
XFILLER_11_145 VPWR VGND VPWR VGND sky130_ef_sc_hd__decap_40_12
Xhold3 rng_rd.wr_ff2_d VGND VGND VPWR VPWR net22 sky130_fd_sc_hd__dlygate4sd3_1
XPHY_EDGE_ROW_9_Left_32 VGND VGND VPWR VPWR sky130_fd_sc_hd__decap_3
XFILLER_0_111 VGND VGND VPWR VPWR sky130_fd_sc_hd__fill_1
XFILLER_5_11 VGND VGND VPWR VPWR sky130_fd_sc_hd__fill_1
XFILLER_5_55 VGND VGND VPWR VPWR sky130_fd_sc_hd__fill_1
XFILLER_5_77 VGND VGND VPWR VPWR sky130_fd_sc_hd__fill_2
XFILLER_14_31 VGND VGND VPWR VPWR sky130_fd_sc_hd__fill_1
XPHY_EDGE_ROW_22_Left_45 VGND VGND VPWR VPWR sky130_fd_sc_hd__decap_3
X_194_ net48 rng_rd.mem\[5\]\[2\] net9 VGND VGND VPWR VPWR _011_ sky130_fd_sc_hd__mux2_1
X_263_ clknet_2_1__leaf_clk_i _035_ net19 VGND VGND VPWR VPWR rng_rd.vld\[5\] sky130_fd_sc_hd__dfrtp_1
XTAP_TAPCELL_ROW_11_76 VGND VPWR sky130_fd_sc_hd__tapvpwrvgnd_1
XTAP_TAPCELL_ROW_7_66 VGND VPWR sky130_fd_sc_hd__tapvpwrvgnd_1
X_177_ net68 _107_ _084_ _086_ VGND VGND VPWR VPWR _006_ sky130_fd_sc_hd__o22a_1
X_246_ clknet_2_1__leaf_clk_i net60 net16 VGND VGND VPWR VPWR rng_rd.mem\[3\]\[1\]
+ sky130_fd_sc_hd__dfrtp_1
XFILLER_22_97 VGND VGND VPWR VPWR sky130_fd_sc_hd__fill_2
X_229_ clknet_2_3__leaf_clk_i net26 net18 VGND VGND VPWR VPWR rng_rd.mem\[7\]\[2\]
+ sky130_fd_sc_hd__dfrtp_1
Xhold4 rng_rd.vld\[7\] VGND VGND VPWR VPWR net23 sky130_fd_sc_hd__dlygate4sd3_1
XFILLER_12_7 VGND VGND VPWR VPWR sky130_fd_sc_hd__fill_2
XPHY_EDGE_ROW_17_Right_17 VGND VGND VPWR VPWR sky130_fd_sc_hd__decap_3
XFILLER_5_34 VPWR VGND VPWR VGND sky130_ef_sc_hd__decap_40_12
X_262_ clknet_2_1__leaf_clk_i net30 net16 VGND VGND VPWR VPWR rng_rd.vld\[4\] sky130_fd_sc_hd__dfrtp_1
X_193_ net46 rng_rd.mem\[5\]\[1\] net9 VGND VGND VPWR VPWR _010_ sky130_fd_sc_hd__mux2_1
XFILLER_2_24 VGND VGND VPWR VPWR sky130_fd_sc_hd__fill_4
XTAP_TAPCELL_ROW_11_77 VGND VPWR sky130_fd_sc_hd__tapvpwrvgnd_1
XTAP_TAPCELL_ROW_7_67 VGND VPWR sky130_fd_sc_hd__tapvpwrvgnd_1
X_176_ rng_dp.seed_sel_i\[1\] rng_dp.seed_sel_i\[0\] _085_ _108_ VGND VGND VPWR VPWR
+ _086_ sky130_fd_sc_hd__a31o_1
X_245_ clknet_2_3__leaf_clk_i _018_ net14 VGND VGND VPWR VPWR rng_rd.mem\[3\]\[0\]
+ sky130_fd_sc_hd__dfrtp_1
XFILLER_0_3 VGND VGND VPWR VPWR sky130_fd_sc_hd__fill_1
X_228_ clknet_2_3__leaf_clk_i net28 net17 VGND VGND VPWR VPWR rng_rd.mem\[7\]\[1\]
+ sky130_fd_sc_hd__dfrtp_1
X_159_ rng_rd.wr_pulse _070_ _071_ VGND VGND VPWR VPWR _072_ sky130_fd_sc_hd__and3_1
XFILLER_17_87 VGND VGND VPWR VPWR sky130_fd_sc_hd__fill_4
XFILLER_17_54 VGND VGND VPWR VPWR sky130_fd_sc_hd__fill_2
XFILLER_3_110 VGND VGND VPWR VPWR sky130_fd_sc_hd__fill_2
Xhold5 _037_ VGND VGND VPWR VPWR net24 sky130_fd_sc_hd__dlygate4sd3_1
XFILLER_0_113 VPWR VGND VPWR VGND sky130_ef_sc_hd__decap_40_12
XFILLER_5_46 VGND VGND VPWR VPWR sky130_fd_sc_hd__fill_4
X_192_ net42 rng_rd.mem\[5\]\[0\] net9 VGND VGND VPWR VPWR _009_ sky130_fd_sc_hd__mux2_1
X_261_ clknet_2_1__leaf_clk_i _033_ net16 VGND VGND VPWR VPWR rng_rd.vld\[3\] sky130_fd_sc_hd__dfrtp_1
XFILLER_17_142 VPWR VGND VPWR VGND sky130_ef_sc_hd__decap_40_12
X_175_ _078_ _081_ VGND VGND VPWR VPWR _085_ sky130_fd_sc_hd__nand2_1
X_244_ clknet_2_0__leaf_clk_i net3 net14 VGND VGND VPWR VPWR rng_rd.wr_ff1 sky130_fd_sc_hd__dfrtp_1
XFILLER_20_137 VGND VGND VPWR VPWR sky130_fd_sc_hd__fill_2
XFILLER_22_55 VGND VGND VPWR VPWR sky130_fd_sc_hd__fill_1
X_158_ rng_dp.seed_sel_i\[1\] net70 VGND VGND VPWR VPWR _002_ sky130_fd_sc_hd__xor2_1
X_227_ clknet_2_3__leaf_clk_i net36 net17 VGND VGND VPWR VPWR rng_rd.mem\[7\]\[0\]
+ sky130_fd_sc_hd__dfrtp_1
XFILLER_17_11 VGND VGND VPWR VPWR sky130_fd_sc_hd__fill_1
XTAP_TAPCELL_ROW_4_58 VGND VPWR sky130_fd_sc_hd__tapvpwrvgnd_1
Xhold6 rng_rd.mem\[7\]\[2\] VGND VGND VPWR VPWR net25 sky130_fd_sc_hd__dlygate4sd3_1
XPHY_EDGE_ROW_3_Right_3 VGND VGND VPWR VPWR sky130_fd_sc_hd__decap_3
XFILLER_0_125 VPWR VGND VPWR VGND sky130_ef_sc_hd__decap_40_12
XFILLER_14_56 VGND VGND VPWR VPWR sky130_fd_sc_hd__fill_2
X_260_ clknet_2_0__leaf_clk_i _032_ net14 VGND VGND VPWR VPWR rng_rd.vld\[2\] sky130_fd_sc_hd__dfrtp_1
XFILLER_17_154 VGND VGND VPWR VPWR sky130_fd_sc_hd__fill_2
X_191_ net32 _107_ _098_ VGND VGND VPWR VPWR _008_ sky130_fd_sc_hd__o21a_1
XFILLER_11_57 VGND VGND VPWR VPWR sky130_fd_sc_hd__fill_2
X_243_ clknet_2_1__leaf_clk_i _017_ net16 VGND VGND VPWR VPWR rng_rd.mem\[4\]\[2\]
+ sky130_fd_sc_hd__dfrtp_1
X_174_ _076_ _079_ _083_ _103_ _080_ VGND VGND VPWR VPWR _084_ sky130_fd_sc_hd__o221a_1
X_157_ net22 net21 VGND VGND VPWR VPWR _000_ sky130_fd_sc_hd__and2b_1
X_226_ rng_dp.inst.next_num_o\[0\] _107_ _087_ _101_ VGND VGND VPWR VPWR _040_ sky130_fd_sc_hd__a31o_1
XFILLER_17_78 VGND VGND VPWR VPWR sky130_fd_sc_hd__fill_1
Xhold7 _005_ VGND VGND VPWR VPWR net26 sky130_fd_sc_hd__dlygate4sd3_1
XTAP_TAPCELL_ROW_4_59 VGND VPWR sky130_fd_sc_hd__tapvpwrvgnd_1
XFILLER_0_70 VGND VGND VPWR VPWR sky130_fd_sc_hd__fill_8
X_209_ net53 net6 net7 VGND VGND VPWR VPWR _026_ sky130_fd_sc_hd__mux2_1
XPHY_EDGE_ROW_13_Left_36 VGND VGND VPWR VPWR sky130_fd_sc_hd__decap_3
XFILLER_0_137 VGND VGND VPWR VPWR sky130_fd_sc_hd__fill_2
XPHY_EDGE_ROW_22_Right_22 VGND VGND VPWR VPWR sky130_fd_sc_hd__decap_3
XPHY_EDGE_ROW_13_Right_13 VGND VGND VPWR VPWR sky130_fd_sc_hd__decap_3
XFILLER_10_7 VGND VGND VPWR VPWR sky130_fd_sc_hd__fill_2
XFILLER_14_24 VGND VGND VPWR VPWR sky130_fd_sc_hd__fill_4
X_190_ _080_ _095_ _096_ _097_ _108_ VGND VGND VPWR VPWR _098_ sky130_fd_sc_hd__a221o_1
Xclkbuf_2_1__f_clk_i clknet_0_clk_i VGND VGND VPWR VPWR clknet_2_1__leaf_clk_i sky130_fd_sc_hd__clkbuf_16
X_242_ clknet_2_1__leaf_clk_i net56 net16 VGND VGND VPWR VPWR rng_rd.mem\[4\]\[1\]
+ sky130_fd_sc_hd__dfrtp_1
X_173_ _102_ rng_dp.inst.next_num_o\[1\] VGND VGND VPWR VPWR _083_ sky130_fd_sc_hd__or2_1
XPHY_EDGE_ROW_1_Left_24 VGND VGND VPWR VPWR sky130_fd_sc_hd__decap_3
XFILLER_20_139 VGND VGND VPWR VPWR sky130_fd_sc_hd__fill_1
XFILLER_22_57 VPWR VGND VPWR VGND sky130_ef_sc_hd__decap_40_12
XTAP_TAPCELL_ROW_21_101 VGND VPWR sky130_fd_sc_hd__tapvpwrvgnd_1
X_225_ rng_dp.inst.next_num_o\[0\] rng_dp.inst.next_num_o\[1\] _107_ _102_ VGND VGND
+ VPWR VPWR _101_ sky130_fd_sc_hd__a31oi_1
X_156_ _070_ _071_ _108_ VGND VGND VPWR VPWR req_num_again sky130_fd_sc_hd__a21oi_1
XFILLER_17_57 VPWR VGND VPWR VGND sky130_ef_sc_hd__decap_40_12
XFILLER_17_46 VGND VGND VPWR VPWR sky130_fd_sc_hd__fill_8
Xhold8 rng_rd.mem\[7\]\[1\] VGND VGND VPWR VPWR net27 sky130_fd_sc_hd__dlygate4sd3_1
XFILLER_3_113 VGND VGND VPWR VPWR sky130_fd_sc_hd__fill_1
X_139_ _105_ rng_rd.mem\[6\]\[1\] rng_rd.vld\[6\] _053_ VGND VGND VPWR VPWR _055_
+ sky130_fd_sc_hd__o211ai_1
X_208_ net66 net5 net7 VGND VGND VPWR VPWR _025_ sky130_fd_sc_hd__mux2_1
XFILLER_6_70 VGND VGND VPWR VPWR sky130_fd_sc_hd__fill_8
XFILLER_6_81 VGND VGND VPWR VPWR sky130_fd_sc_hd__fill_2
XFILLER_9_3 VGND VGND VPWR VPWR sky130_fd_sc_hd__fill_1
XFILLER_17_156 VGND VGND VPWR VPWR sky130_fd_sc_hd__fill_1
XFILLER_11_59 VGND VGND VPWR VPWR sky130_fd_sc_hd__fill_1
X_172_ _102_ rng_dp.inst.next_num_o\[1\] VGND VGND VPWR VPWR _082_ sky130_fd_sc_hd__nor2_1
X_241_ clknet_2_1__leaf_clk_i _015_ net16 VGND VGND VPWR VPWR rng_rd.mem\[4\]\[0\]
+ sky130_fd_sc_hd__dfrtp_1
XFILLER_22_69 VPWR VGND VPWR VGND sky130_ef_sc_hd__decap_40_12
XFILLER_22_47 VGND VGND VPWR VPWR sky130_fd_sc_hd__fill_8
XTAP_TAPCELL_ROW_21_102 VGND VPWR sky130_fd_sc_hd__tapvpwrvgnd_1
X_224_ rng_dp.inst.next_num_o\[1\] _099_ VGND VGND VPWR VPWR _039_ sky130_fd_sc_hd__xnor2_1
XFILLER_8_27 VGND VGND VPWR VPWR sky130_fd_sc_hd__fill_1
XTAP_TAPCELL_ROW_12_80 VGND VPWR sky130_fd_sc_hd__tapvpwrvgnd_1
X_155_ _112_ _052_ _061_ _065_ VGND VGND VPWR VPWR _071_ sky130_fd_sc_hd__and4_1
XTAP_TAPCELL_ROW_8_70 VGND VPWR sky130_fd_sc_hd__tapvpwrvgnd_1
Xhold9 _004_ VGND VGND VPWR VPWR net28 sky130_fd_sc_hd__dlygate4sd3_1
X_138_ net12 rng_rd.mem\[6\]\[0\] rng_rd.mem\[6\]\[1\] _105_ VGND VGND VPWR VPWR _054_
+ sky130_fd_sc_hd__a2bb2o_1
X_207_ net65 net4 net7 VGND VGND VPWR VPWR _024_ sky130_fd_sc_hd__mux2_1
XFILLER_0_139 VGND VGND VPWR VPWR sky130_fd_sc_hd__fill_1
XFILLER_0_83 VGND VGND VPWR VPWR sky130_fd_sc_hd__fill_1
XFILLER_5_17 VGND VGND VPWR VPWR sky130_fd_sc_hd__fill_4
XFILLER_10_9 VGND VGND VPWR VPWR sky130_fd_sc_hd__fill_1
XPHY_EDGE_ROW_7_Right_7 VGND VGND VPWR VPWR sky130_fd_sc_hd__decap_3
XFILLER_6_93 VGND VGND VPWR VPWR sky130_fd_sc_hd__fill_2
XFILLER_17_113 VGND VGND VPWR VPWR sky130_fd_sc_hd__fill_4
XFILLER_2_29 VGND VGND VPWR VPWR sky130_fd_sc_hd__fill_4
X_240_ clknet_2_1__leaf_clk_i _014_ net16 VGND VGND VPWR VPWR rng_rd.mem\[5\]\[2\]
+ sky130_fd_sc_hd__dfrtp_1
XFILLER_14_138 VGND VGND VPWR VPWR sky130_fd_sc_hd__fill_2
X_171_ rng_dp.inst.next_num_o\[2\] rng_dp.inst.next_num_o\[0\] VGND VGND VPWR VPWR
+ _081_ sky130_fd_sc_hd__nand2_1
XFILLER_22_37 VGND VGND VPWR VPWR sky130_fd_sc_hd__fill_2
XFILLER_22_15 VPWR VGND VPWR VGND sky130_ef_sc_hd__decap_40_12
X_223_ _099_ _100_ VGND VGND VPWR VPWR _038_ sky130_fd_sc_hd__and2_1
XFILLER_8_39 VGND VGND VPWR VPWR sky130_fd_sc_hd__fill_1
XFILLER_10_141 VPWR VGND VPWR VGND sky130_ef_sc_hd__decap_40_12
X_154_ _044_ _048_ _056_ _069_ VGND VGND VPWR VPWR _070_ sky130_fd_sc_hd__and4_1
XFILLER_12_81 VGND VGND VPWR VPWR sky130_fd_sc_hd__fill_2
X_137_ net13 rng_rd.mem\[6\]\[2\] VGND VGND VPWR VPWR _053_ sky130_fd_sc_hd__xnor2_1
X_206_ net58 net53 net8 VGND VGND VPWR VPWR _023_ sky130_fd_sc_hd__mux2_1
XFILLER_17_3 VGND VGND VPWR VPWR sky130_fd_sc_hd__fill_8
XFILLER_9_82 VPWR VGND VPWR VGND sky130_ef_sc_hd__decap_40_12
XTAP_TAPCELL_ROW_5_61 VGND VPWR sky130_fd_sc_hd__tapvpwrvgnd_1
XFILLER_6_83 VGND VGND VPWR VPWR sky130_fd_sc_hd__fill_1
XFILLER_15_70 VGND VGND VPWR VPWR sky130_fd_sc_hd__fill_2
X_170_ rng_dp.seed_sel_i\[1\] rng_dp.seed_sel_i\[0\] VGND VGND VPWR VPWR _080_ sky130_fd_sc_hd__nand2_1
XFILLER_22_27 VGND VGND VPWR VPWR sky130_fd_sc_hd__fill_1
XPHY_EDGE_ROW_5_Left_28 VGND VGND VPWR VPWR sky130_fd_sc_hd__decap_3
X_222_ rng_dp.inst.next_num_o\[0\] _107_ VGND VGND VPWR VPWR _100_ sky130_fd_sc_hd__or2_1
X_153_ net11 rng_rd.mem\[1\]\[0\] _066_ _068_ VGND VGND VPWR VPWR _069_ sky130_fd_sc_hd__a211o_1
XFILLER_8_29 VGND VGND VPWR VPWR sky130_fd_sc_hd__fill_1
XFILLER_10_153 VGND VGND VPWR VPWR sky130_fd_sc_hd__fill_4
X_205_ net62 rng_rd.mem\[1\]\[1\] net7 VGND VGND VPWR VPWR _022_ sky130_fd_sc_hd__mux2_1
X_136_ net12 rng_rd.mem\[3\]\[0\] _049_ _051_ VGND VGND VPWR VPWR _052_ sky130_fd_sc_hd__a211o_1
XFILLER_0_85 VPWR VGND VPWR VGND sky130_ef_sc_hd__decap_40_12
XFILLER_9_94 VGND VGND VPWR VPWR sky130_fd_sc_hd__fill_4
XPHY_EDGE_ROW_8_Left_31 VGND VGND VPWR VPWR sky130_fd_sc_hd__decap_3
X_119_ net1 req_num_again VGND VGND VPWR VPWR _107_ sky130_fd_sc_hd__or2_2
XTAP_TAPCELL_ROW_5_62 VGND VPWR sky130_fd_sc_hd__tapvpwrvgnd_1
XFILLER_7_3 VGND VGND VPWR VPWR sky130_fd_sc_hd__fill_8
XPHY_EDGE_ROW_21_Left_44 VGND VGND VPWR VPWR sky130_fd_sc_hd__decap_3
XFILLER_3_52 VGND VGND VPWR VPWR sky130_fd_sc_hd__fill_4
XFILLER_9_100 VGND VGND VPWR VPWR sky130_fd_sc_hd__fill_1
X_221_ rng_dp.inst.next_num_o\[0\] _107_ VGND VGND VPWR VPWR _099_ sky130_fd_sc_hd__nand2_1
X_152_ net11 rng_rd.mem\[1\]\[0\] rng_rd.vld\[1\] _067_ VGND VGND VPWR VPWR _068_
+ sky130_fd_sc_hd__o211ai_1
XFILLER_10_121 VPWR VGND VPWR VGND sky130_ef_sc_hd__decap_40_12
XFILLER_12_83 VGND VGND VPWR VPWR sky130_fd_sc_hd__fill_1
X_204_ net40 rng_rd.mem\[1\]\[0\] net10 VGND VGND VPWR VPWR _021_ sky130_fd_sc_hd__mux2_1
XFILLER_0_97 VPWR VGND VPWR VGND sky130_ef_sc_hd__decap_40_12
X_135_ net12 rng_rd.mem\[3\]\[0\] rng_rd.vld\[3\] _050_ VGND VGND VPWR VPWR _051_
+ sky130_fd_sc_hd__o211ai_1
XTAP_TAPCELL_ROW_18_93 VGND VPWR sky130_fd_sc_hd__tapvpwrvgnd_1
XFILLER_0_109 VGND VGND VPWR VPWR sky130_fd_sc_hd__fill_2
X_118_ rng_rd.vld\[0\] VGND VGND VPWR VPWR _106_ sky130_fd_sc_hd__inv_2
XFILLER_22_3 VPWR VGND VPWR VGND sky130_ef_sc_hd__decap_40_12
XFILLER_14_29 VGND VGND VPWR VPWR sky130_fd_sc_hd__fill_2
XFILLER_20_94 VGND VGND VPWR VPWR sky130_fd_sc_hd__fill_1
XFILLER_20_83 VGND VGND VPWR VPWR sky130_fd_sc_hd__fill_1
XFILLER_6_85 VGND VGND VPWR VPWR sky130_fd_sc_hd__fill_8
XFILLER_15_72 VGND VGND VPWR VPWR sky130_fd_sc_hd__fill_1
XFILLER_15_61 VGND VGND VPWR VPWR sky130_fd_sc_hd__fill_1
XTAP_TAPCELL_ROW_2_53 VGND VPWR sky130_fd_sc_hd__tapvpwrvgnd_1
XFILLER_22_141 VPWR VGND VPWR VGND sky130_ef_sc_hd__decap_40_12
XFILLER_3_97 VGND VGND VPWR VPWR sky130_fd_sc_hd__fill_1
X_220_ net23 rng_rd.vld\[6\] net9 VGND VGND VPWR VPWR _037_ sky130_fd_sc_hd__mux2_1
X_151_ num_i_bar\[1\] rng_rd.mem\[1\]\[1\] VGND VGND VPWR VPWR _067_ sky130_fd_sc_hd__xnor2_1
XFILLER_6_137 VGND VGND VPWR VPWR sky130_fd_sc_hd__fill_2
XFILLER_10_133 VGND VGND VPWR VPWR sky130_fd_sc_hd__fill_4
XFILLER_12_73 VGND VGND VPWR VPWR sky130_fd_sc_hd__fill_8
X_203_ net50 rng_rd.mem\[2\]\[2\] net8 VGND VGND VPWR VPWR _020_ sky130_fd_sc_hd__mux2_1
X_134_ num_i_bar\[1\] rng_rd.mem\[3\]\[1\] VGND VGND VPWR VPWR _050_ sky130_fd_sc_hd__xnor2_1
XFILLER_0_65 VGND VGND VPWR VPWR sky130_fd_sc_hd__fill_1
XTAP_TAPCELL_ROW_18_94 VGND VPWR sky130_fd_sc_hd__tapvpwrvgnd_1
X_117_ num_i_bar\[1\] VGND VGND VPWR VPWR _105_ sky130_fd_sc_hd__inv_2
XFILLER_15_3 VPWR VGND VPWR VGND sky130_ef_sc_hd__decap_40_12
XFILLER_15_51 VGND VGND VPWR VPWR sky130_fd_sc_hd__fill_4
XTAP_TAPCELL_ROW_2_54 VGND VPWR sky130_fd_sc_hd__tapvpwrvgnd_1
Xoutput4 net4 VGND VGND VPWR VPWR num_to_send_o[0] sky130_fd_sc_hd__buf_2
XFILLER_22_153 VGND VGND VPWR VPWR sky130_fd_sc_hd__fill_4
XFILLER_9_113 VPWR VGND VPWR VGND sky130_ef_sc_hd__decap_40_12
XFILLER_3_76 VGND VGND VPWR VPWR sky130_fd_sc_hd__fill_1
XFILLER_6_149 VGND VGND VPWR VPWR sky130_fd_sc_hd__fill_8
X_150_ net13 rng_rd.mem\[1\]\[2\] VGND VGND VPWR VPWR _066_ sky130_fd_sc_hd__xor2_1
XPHY_EDGE_ROW_16_Right_16 VGND VGND VPWR VPWR sky130_fd_sc_hd__decap_3
X_133_ net13 rng_rd.mem\[3\]\[2\] VGND VGND VPWR VPWR _049_ sky130_fd_sc_hd__xor2_1
X_202_ net59 rng_rd.mem\[2\]\[1\] net8 VGND VGND VPWR VPWR _019_ sky130_fd_sc_hd__mux2_1
XFILLER_0_55 VGND VGND VPWR VPWR sky130_fd_sc_hd__fill_1
XTAP_TAPCELL_ROW_18_95 VGND VPWR sky130_fd_sc_hd__tapvpwrvgnd_1
X_116_ num_i_bar\[0\] VGND VGND VPWR VPWR _104_ sky130_fd_sc_hd__inv_2
XPHY_EDGE_ROW_2_Right_2 VGND VGND VPWR VPWR sky130_fd_sc_hd__decap_3
Xhold50 rng_dp.seed_sel_i\[0\] VGND VGND VPWR VPWR net69 sky130_fd_sc_hd__dlygate4sd3_1
XFILLER_15_41 VGND VGND VPWR VPWR sky130_fd_sc_hd__fill_2
XTAP_TAPCELL_ROW_2_55 VGND VPWR sky130_fd_sc_hd__tapvpwrvgnd_1
Xoutput5 net5 VGND VGND VPWR VPWR num_to_send_o[1] sky130_fd_sc_hd__buf_2
XFILLER_9_125 VPWR VGND VPWR VGND sky130_ef_sc_hd__decap_40_12
XFILLER_5_3 VGND VGND VPWR VPWR sky130_fd_sc_hd__fill_8
XFILLER_6_139 VGND VGND VPWR VPWR sky130_fd_sc_hd__fill_1
X_132_ net11 rng_rd.mem\[5\]\[0\] _045_ _047_ VGND VGND VPWR VPWR _048_ sky130_fd_sc_hd__a211o_1
X_201_ net44 net40 net10 VGND VGND VPWR VPWR _018_ sky130_fd_sc_hd__mux2_1
XFILLER_0_78 VGND VGND VPWR VPWR sky130_fd_sc_hd__fill_2
XFILLER_9_98 VGND VGND VPWR VPWR sky130_fd_sc_hd__fill_2
X_115_ net69 VGND VGND VPWR VPWR _001_ sky130_fd_sc_hd__inv_2
XPHY_EDGE_ROW_12_Left_35 VGND VGND VPWR VPWR sky130_fd_sc_hd__decap_3
Xhold40 rng_rd.mem\[3\]\[1\] VGND VGND VPWR VPWR net59 sky130_fd_sc_hd__dlygate4sd3_1
Xhold51 rng_dp.seed_sel_i\[0\] VGND VGND VPWR VPWR net70 sky130_fd_sc_hd__dlygate4sd3_1
XTAP_TAPCELL_ROW_15_86 VGND VPWR sky130_fd_sc_hd__tapvpwrvgnd_1
Xoutput6 net6 VGND VGND VPWR VPWR num_to_send_o[2] sky130_fd_sc_hd__buf_2
XFILLER_16_141 VPWR VGND VPWR VGND sky130_ef_sc_hd__decap_40_12
.ends
