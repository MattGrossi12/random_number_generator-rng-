* NGSPICE file created from rng_top.ext - technology: sky130A

* Black-box entry subcircuit for sky130_fd_sc_hd__tapvpwrvgnd_1 abstract view
.subckt sky130_fd_sc_hd__tapvpwrvgnd_1 VGND VPWR
.ends

* Black-box entry subcircuit for sky130_ef_sc_hd__decap_40_12 abstract view
.subckt sky130_ef_sc_hd__decap_40_12 VPWR VGND VPB VNB
.ends

* Black-box entry subcircuit for sky130_fd_sc_hd__dfrtp_1 abstract view
.subckt sky130_fd_sc_hd__dfrtp_1 CLK D RESET_B VGND VNB VPB VPWR Q
.ends

* Black-box entry subcircuit for sky130_fd_sc_hd__mux2_1 abstract view
.subckt sky130_fd_sc_hd__mux2_1 A0 A1 S VGND VNB VPB VPWR X
.ends

* Black-box entry subcircuit for sky130_fd_sc_hd__decap_3 abstract view
.subckt sky130_fd_sc_hd__decap_3 VGND VNB VPB VPWR
.ends

* Black-box entry subcircuit for sky130_fd_sc_hd__or4_1 abstract view
.subckt sky130_fd_sc_hd__or4_1 A B C D VGND VNB VPB VPWR X
.ends

* Black-box entry subcircuit for sky130_fd_sc_hd__fill_2 abstract view
.subckt sky130_fd_sc_hd__fill_2 VGND VNB VPB VPWR
.ends

* Black-box entry subcircuit for sky130_fd_sc_hd__o2bb2a_1 abstract view
.subckt sky130_fd_sc_hd__o2bb2a_1 A1_N A2_N B1 B2 VGND VNB VPB VPWR X
.ends

* Black-box entry subcircuit for sky130_fd_sc_hd__xnor2_1 abstract view
.subckt sky130_fd_sc_hd__xnor2_1 A B VGND VNB VPB VPWR Y
.ends

* Black-box entry subcircuit for sky130_fd_sc_hd__clkbuf_4 abstract view
.subckt sky130_fd_sc_hd__clkbuf_4 A VGND VNB VPB VPWR X
.ends

* Black-box entry subcircuit for sky130_fd_sc_hd__dlygate4sd3_1 abstract view
.subckt sky130_fd_sc_hd__dlygate4sd3_1 A VGND VNB VPB VPWR X
.ends

* Black-box entry subcircuit for sky130_fd_sc_hd__fill_4 abstract view
.subckt sky130_fd_sc_hd__fill_4 VGND VNB VPB VPWR
.ends

* Black-box entry subcircuit for sky130_fd_sc_hd__fill_1 abstract view
.subckt sky130_fd_sc_hd__fill_1 VGND VNB VPB VPWR
.ends

* Black-box entry subcircuit for sky130_fd_sc_hd__o21a_1 abstract view
.subckt sky130_fd_sc_hd__o21a_1 A1 A2 B1 VGND VNB VPB VPWR X
.ends

* Black-box entry subcircuit for sky130_fd_sc_hd__or3_1 abstract view
.subckt sky130_fd_sc_hd__or3_1 A B C VGND VNB VPB VPWR X
.ends

* Black-box entry subcircuit for sky130_fd_sc_hd__nor2_1 abstract view
.subckt sky130_fd_sc_hd__nor2_1 A B VGND VNB VPB VPWR Y
.ends

* Black-box entry subcircuit for sky130_fd_sc_hd__fill_8 abstract view
.subckt sky130_fd_sc_hd__fill_8 VGND VNB VPB VPWR
.ends

* Black-box entry subcircuit for sky130_fd_sc_hd__nand2_1 abstract view
.subckt sky130_fd_sc_hd__nand2_1 A B VGND VNB VPB VPWR Y
.ends

* Black-box entry subcircuit for sky130_fd_sc_hd__a21oi_1 abstract view
.subckt sky130_fd_sc_hd__a21oi_1 A1 A2 B1 VGND VNB VPB VPWR Y
.ends

* Black-box entry subcircuit for sky130_fd_sc_hd__clkbuf_16 abstract view
.subckt sky130_fd_sc_hd__clkbuf_16 A VGND VNB VPB VPWR X
.ends

* Black-box entry subcircuit for sky130_fd_sc_hd__o311a_1 abstract view
.subckt sky130_fd_sc_hd__o311a_1 A1 A2 A3 B1 C1 VGND VNB VPB VPWR X
.ends

* Black-box entry subcircuit for sky130_fd_sc_hd__and3_1 abstract view
.subckt sky130_fd_sc_hd__and3_1 A B C VGND VNB VPB VPWR X
.ends

* Black-box entry subcircuit for sky130_fd_sc_hd__o221a_1 abstract view
.subckt sky130_fd_sc_hd__o221a_1 A1 A2 B1 B2 C1 VGND VNB VPB VPWR X
.ends

* Black-box entry subcircuit for sky130_fd_sc_hd__a211o_1 abstract view
.subckt sky130_fd_sc_hd__a211o_1 A1 A2 B1 C1 VGND VNB VPB VPWR X
.ends

* Black-box entry subcircuit for sky130_fd_sc_hd__clkbuf_8 abstract view
.subckt sky130_fd_sc_hd__clkbuf_8 A VGND VNB VPB VPWR X
.ends

* Black-box entry subcircuit for sky130_fd_sc_hd__and3b_1 abstract view
.subckt sky130_fd_sc_hd__and3b_1 A_N B C VGND VNB VPB VPWR X
.ends

* Black-box entry subcircuit for sky130_fd_sc_hd__inv_2 abstract view
.subckt sky130_fd_sc_hd__inv_2 A VGND VNB VPB VPWR Y
.ends

* Black-box entry subcircuit for sky130_fd_sc_hd__dfrtp_2 abstract view
.subckt sky130_fd_sc_hd__dfrtp_2 CLK D RESET_B VGND VNB VPB VPWR Q
.ends

* Black-box entry subcircuit for sky130_fd_sc_hd__and2_1 abstract view
.subckt sky130_fd_sc_hd__and2_1 A B VGND VNB VPB VPWR X
.ends

* Black-box entry subcircuit for sky130_fd_sc_hd__a22o_1 abstract view
.subckt sky130_fd_sc_hd__a22o_1 A1 A2 B1 B2 VGND VNB VPB VPWR X
.ends

* Black-box entry subcircuit for sky130_fd_sc_hd__o22a_1 abstract view
.subckt sky130_fd_sc_hd__o22a_1 A1 A2 B1 B2 VGND VNB VPB VPWR X
.ends

* Black-box entry subcircuit for sky130_fd_sc_hd__clkinv_2 abstract view
.subckt sky130_fd_sc_hd__clkinv_2 A VGND VNB VPB VPWR Y
.ends

* Black-box entry subcircuit for sky130_fd_sc_hd__xor2_1 abstract view
.subckt sky130_fd_sc_hd__xor2_1 A B VGND VNB VPB VPWR X
.ends

* Black-box entry subcircuit for sky130_fd_sc_hd__and4_1 abstract view
.subckt sky130_fd_sc_hd__and4_1 A B C D VGND VNB VPB VPWR X
.ends

* Black-box entry subcircuit for sky130_fd_sc_hd__or3b_1 abstract view
.subckt sky130_fd_sc_hd__or3b_1 A B C_N VGND VNB VPB VPWR X
.ends

* Black-box entry subcircuit for sky130_fd_sc_hd__or2_1 abstract view
.subckt sky130_fd_sc_hd__or2_1 A B VGND VNB VPB VPWR X
.ends

* Black-box entry subcircuit for sky130_fd_sc_hd__buf_2 abstract view
.subckt sky130_fd_sc_hd__buf_2 A VGND VNB VPB VPWR X
.ends

* Black-box entry subcircuit for sky130_fd_sc_hd__o211a_1 abstract view
.subckt sky130_fd_sc_hd__o211a_1 A1 A2 B1 C1 VGND VNB VPB VPWR X
.ends

* Black-box entry subcircuit for sky130_fd_sc_hd__clkbuf_1 abstract view
.subckt sky130_fd_sc_hd__clkbuf_1 A VGND VNB VPB VPWR X
.ends

* Black-box entry subcircuit for sky130_fd_sc_hd__clkbuf_2 abstract view
.subckt sky130_fd_sc_hd__clkbuf_2 A VGND VNB VPB VPWR X
.ends

* Black-box entry subcircuit for sky130_fd_sc_hd__a221o_1 abstract view
.subckt sky130_fd_sc_hd__a221o_1 A1 A2 B1 B2 C1 VGND VNB VPB VPWR X
.ends

* Black-box entry subcircuit for sky130_fd_sc_hd__o22ai_1 abstract view
.subckt sky130_fd_sc_hd__o22ai_1 A1 A2 B1 B2 VGND VNB VPB VPWR Y
.ends

* Black-box entry subcircuit for sky130_fd_sc_hd__dlymetal6s2s_1 abstract view
.subckt sky130_fd_sc_hd__dlymetal6s2s_1 A VGND VNB VPB VPWR X
.ends

* Black-box entry subcircuit for sky130_fd_sc_hd__o32a_1 abstract view
.subckt sky130_fd_sc_hd__o32a_1 A1 A2 A3 B1 B2 VGND VNB VPB VPWR X
.ends

* Black-box entry subcircuit for sky130_fd_sc_hd__dfrtp_4 abstract view
.subckt sky130_fd_sc_hd__dfrtp_4 CLK D RESET_B VGND VNB VPB VPWR Q
.ends

* Black-box entry subcircuit for sky130_fd_sc_hd__a21o_1 abstract view
.subckt sky130_fd_sc_hd__a21o_1 A1 A2 B1 VGND VNB VPB VPWR X
.ends

* Black-box entry subcircuit for sky130_fd_sc_hd__and2b_1 abstract view
.subckt sky130_fd_sc_hd__and2b_1 A_N B VGND VNB VPB VPWR X
.ends

* Black-box entry subcircuit for sky130_fd_sc_hd__o31a_1 abstract view
.subckt sky130_fd_sc_hd__o31a_1 A1 A2 A3 B1 VGND VNB VPB VPWR X
.ends

* Black-box entry subcircuit for sky130_fd_sc_hd__a22oi_1 abstract view
.subckt sky130_fd_sc_hd__a22oi_1 A1 A2 B1 B2 VGND VNB VPB VPWR Y
.ends

* Black-box entry subcircuit for sky130_fd_sc_hd__or2_2 abstract view
.subckt sky130_fd_sc_hd__or2_2 A B VGND VNB VPB VPWR X
.ends

* Black-box entry subcircuit for sky130_fd_sc_hd__o21ai_1 abstract view
.subckt sky130_fd_sc_hd__o21ai_1 A1 A2 B1 VGND VNB VPB VPWR Y
.ends

* Black-box entry subcircuit for sky130_fd_sc_hd__nor4_1 abstract view
.subckt sky130_fd_sc_hd__nor4_1 A B C D VGND VNB VPB VPWR Y
.ends

* Black-box entry subcircuit for sky130_fd_sc_hd__a32o_1 abstract view
.subckt sky130_fd_sc_hd__a32o_1 A1 A2 A3 B1 B2 VGND VNB VPB VPWR X
.ends

.subckt rng_top VGND VPWR clk_i num_to_send_o[0] num_to_send_o[1] num_to_send_o[2]
+ req_num_i rst_i wr_i
XTAP_TAPCELL_ROW_32_183 VGND VPWR sky130_fd_sc_hd__tapvpwrvgnd_1
XTAP_TAPCELL_ROW_9_104 VGND VPWR sky130_fd_sc_hd__tapvpwrvgnd_1
XFILLER_26_85 VPWR VGND VPWR VGND sky130_ef_sc_hd__decap_40_12
XFILLER_26_41 VPWR VGND VPWR VGND sky130_ef_sc_hd__decap_40_12
X_363_ clknet_3_2__leaf_clk_i _030_ net22 VGND VGND VPWR VPWR rng_rd.mem\[1\]\[0\]
+ sky130_fd_sc_hd__dfrtp_1
X_294_ net56 net68 net10 VGND VGND VPWR VPWR _020_ sky130_fd_sc_hd__mux2_1
XTAP_TAPCELL_ROW_20_142 VGND VPWR sky130_fd_sc_hd__tapvpwrvgnd_1
XPHY_EDGE_ROW_0_Left_34 VGND VGND VPWR VPWR sky130_fd_sc_hd__decap_3
X_346_ clknet_3_5__leaf_clk_i _014_ net24 VGND VGND VPWR VPWR rng_rd.mem\[10\]\[2\]
+ sky130_fd_sc_hd__dfrtp_1
XTAP_TAPCELL_ROW_8_99 VGND VPWR sky130_fd_sc_hd__tapvpwrvgnd_1
X_277_ rng_dp.seed_sel_i\[1\] rng_dp.seed_sel_i\[0\] _140_ _158_ VGND VGND VPWR VPWR
+ _159_ sky130_fd_sc_hd__or4_1
XFILLER_5_173 VGND VGND VPWR VPWR sky130_fd_sc_hd__fill_2
XFILLER_30_209 VPWR VGND VPWR VGND sky130_ef_sc_hd__decap_40_12
X_200_ net15 rng_rd.mem\[10\]\[0\] rng_rd.mem\[10\]\[1\] net13 VGND VGND VPWR VPWR
+ _090_ sky130_fd_sc_hd__o2bb2a_1
X_329_ _065_ _164_ VGND VGND VPWR VPWR _053_ sky130_fd_sc_hd__xnor2_1
XFILLER_0_57 VPWR VGND VPWR VGND sky130_ef_sc_hd__decap_40_12
XFILLER_2_165 VPWR VGND VPWR VGND sky130_ef_sc_hd__decap_40_12
XFILLER_11_220 VGND VGND VPWR VPWR sky130_fd_sc_hd__fill_2
XTAP_TAPCELL_ROW_5_89 VGND VPWR sky130_fd_sc_hd__tapvpwrvgnd_1
Xfanout7 net8 VGND VGND VPWR VPWR net7 sky130_fd_sc_hd__clkbuf_4
Xhold30 rng_rd.mem\[3\]\[1\] VGND VGND VPWR VPWR net57 sky130_fd_sc_hd__dlygate4sd3_1
Xhold63 rng_rd.mem\[5\]\[0\] VGND VGND VPWR VPWR net90 sky130_fd_sc_hd__dlygate4sd3_1
Xhold41 rng_rd.mem\[4\]\[2\] VGND VGND VPWR VPWR net68 sky130_fd_sc_hd__dlygate4sd3_1
Xhold52 _032_ VGND VGND VPWR VPWR net79 sky130_fd_sc_hd__dlygate4sd3_1
XFILLER_26_109 VPWR VGND VPWR VGND sky130_ef_sc_hd__decap_40_12
XFILLER_6_45 VGND VGND VPWR VPWR sky130_fd_sc_hd__fill_2
XFILLER_6_78 VGND VGND VPWR VPWR sky130_fd_sc_hd__fill_4
XFILLER_15_98 VGND VGND VPWR VPWR sky130_fd_sc_hd__fill_1
XFILLER_31_167 VGND VGND VPWR VPWR sky130_fd_sc_hd__fill_1
XTAP_TAPCELL_ROW_18_137 VGND VPWR sky130_fd_sc_hd__tapvpwrvgnd_1
XFILLER_16_197 VPWR VGND VPWR VGND sky130_ef_sc_hd__decap_40_12
XTAP_TAPCELL_ROW_2_79 VGND VPWR sky130_fd_sc_hd__tapvpwrvgnd_1
XTAP_TAPCELL_ROW_32_184 VGND VPWR sky130_fd_sc_hd__tapvpwrvgnd_1
XFILLER_22_189 VGND VGND VPWR VPWR sky130_fd_sc_hd__fill_4
XTAP_TAPCELL_ROW_9_105 VGND VPWR sky130_fd_sc_hd__tapvpwrvgnd_1
XFILLER_26_97 VPWR VGND VPWR VGND sky130_ef_sc_hd__decap_40_12
XFILLER_26_53 VPWR VGND VPWR VGND sky130_ef_sc_hd__decap_40_12
X_293_ net73 rng_rd.mem\[4\]\[1\] net10 VGND VGND VPWR VPWR _019_ sky130_fd_sc_hd__mux2_1
XFILLER_13_167 VGND VGND VPWR VPWR sky130_fd_sc_hd__fill_1
X_362_ clknet_3_0__leaf_clk_i net70 net21 VGND VGND VPWR VPWR rng_rd.mem\[2\]\[2\]
+ sky130_fd_sc_hd__dfrtp_1
XFILLER_3_24 VGND VGND VPWR VPWR sky130_fd_sc_hd__fill_1
XTAP_TAPCELL_ROW_20_143 VGND VPWR sky130_fd_sc_hd__tapvpwrvgnd_1
XFILLER_10_104 VGND VGND VPWR VPWR sky130_fd_sc_hd__fill_2
XTAP_TAPCELL_ROW_11_110 VGND VPWR sky130_fd_sc_hd__tapvpwrvgnd_1
X_345_ clknet_3_4__leaf_clk_i _013_ net24 VGND VGND VPWR VPWR rng_rd.mem\[10\]\[1\]
+ sky130_fd_sc_hd__dfrtp_1
X_276_ _142_ _145_ rng_dp.inst.next_num_o\[1\] VGND VGND VPWR VPWR _158_ sky130_fd_sc_hd__o21a_1
XFILLER_5_196 VPWR VGND VPWR VGND sky130_ef_sc_hd__decap_40_12
XPHY_EDGE_ROW_21_Right_21 VGND VGND VPWR VPWR sky130_fd_sc_hd__decap_3
XFILLER_15_207 VPWR VGND VPWR VGND sky130_ef_sc_hd__decap_40_12
XPHY_EDGE_ROW_12_Right_12 VGND VGND VPWR VPWR sky130_fd_sc_hd__decap_3
XPHY_EDGE_ROW_30_Right_30 VGND VGND VPWR VPWR sky130_fd_sc_hd__decap_3
XFILLER_0_69 VPWR VGND VPWR VGND sky130_ef_sc_hd__decap_40_12
XFILLER_2_177 VPWR VGND VPWR VGND sky130_ef_sc_hd__decap_40_12
X_259_ _138_ _141_ _142_ VGND VGND VPWR VPWR _143_ sky130_fd_sc_hd__or3_1
X_328_ _164_ _165_ VGND VGND VPWR VPWR _052_ sky130_fd_sc_hd__nor2_1
XFILLER_20_221 VGND VGND VPWR VPWR sky130_fd_sc_hd__fill_2
XFILLER_15_7 VGND VGND VPWR VPWR sky130_fd_sc_hd__fill_4
Xfanout8 net12 VGND VGND VPWR VPWR net8 sky130_fd_sc_hd__clkbuf_4
Xhold31 _022_ VGND VGND VPWR VPWR net58 sky130_fd_sc_hd__dlygate4sd3_1
Xhold64 rng_rd.mem\[8\]\[1\] VGND VGND VPWR VPWR net91 sky130_fd_sc_hd__dlygate4sd3_1
Xhold53 rng_rd.mem\[1\]\[0\] VGND VGND VPWR VPWR net80 sky130_fd_sc_hd__dlygate4sd3_1
Xhold42 rng_rd.mem\[2\]\[2\] VGND VGND VPWR VPWR net69 sky130_fd_sc_hd__dlygate4sd3_1
Xhold20 rng_rd.mem\[11\]\[0\] VGND VGND VPWR VPWR net47 sky130_fd_sc_hd__dlygate4sd3_1
XFILLER_28_195 VGND VGND VPWR VPWR sky130_fd_sc_hd__fill_1
XFILLER_25_165 VGND VGND VPWR VPWR sky130_fd_sc_hd__fill_2
XFILLER_15_11 VGND VGND VPWR VPWR sky130_fd_sc_hd__fill_2
XPHY_EDGE_ROW_6_Right_6 VGND VGND VPWR VPWR sky130_fd_sc_hd__decap_3
XFILLER_31_113 VPWR VGND VPWR VGND sky130_ef_sc_hd__decap_40_12
XTAP_TAPCELL_ROW_32_185 VGND VPWR sky130_fd_sc_hd__tapvpwrvgnd_1
XFILLER_26_65 VPWR VGND VPWR VGND sky130_ef_sc_hd__decap_40_12
XTAP_TAPCELL_ROW_23_152 VGND VPWR sky130_fd_sc_hd__tapvpwrvgnd_1
X_361_ clknet_3_2__leaf_clk_i _028_ net22 VGND VGND VPWR VPWR rng_rd.mem\[2\]\[1\]
+ sky130_fd_sc_hd__dfrtp_1
X_292_ net90 rng_rd.mem\[4\]\[0\] net10 VGND VGND VPWR VPWR _018_ sky130_fd_sc_hd__mux2_1
XFILLER_13_135 VPWR VGND VPWR VGND sky130_ef_sc_hd__decap_40_12
XFILLER_13_113 VGND VGND VPWR VPWR sky130_fd_sc_hd__fill_2
XFILLER_8_161 VGND VGND VPWR VPWR sky130_fd_sc_hd__fill_1
XFILLER_8_194 VGND VGND VPWR VPWR sky130_fd_sc_hd__fill_2
XFILLER_27_205 VPWR VGND VPWR VGND sky130_ef_sc_hd__decap_40_12
XTAP_TAPCELL_ROW_20_144 VGND VPWR sky130_fd_sc_hd__tapvpwrvgnd_1
XFILLER_12_45 VGND VGND VPWR VPWR sky130_fd_sc_hd__fill_4
XTAP_TAPCELL_ROW_11_111 VGND VPWR sky130_fd_sc_hd__tapvpwrvgnd_1
X_275_ _157_ _153_ _136_ net18 VGND VGND VPWR VPWR _007_ sky130_fd_sc_hd__o2bb2a_1
XFILLER_5_175 VGND VGND VPWR VPWR sky130_fd_sc_hd__fill_1
X_344_ clknet_3_5__leaf_clk_i net85 net24 VGND VGND VPWR VPWR rng_rd.mem\[10\]\[0\]
+ sky130_fd_sc_hd__dfrtp_1
XFILLER_15_219 VGND VGND VPWR VPWR sky130_fd_sc_hd__fill_4
XFILLER_23_55 VGND VGND VPWR VPWR sky130_fd_sc_hd__fill_1
XFILLER_2_112 VPWR VGND VPWR VGND sky130_ef_sc_hd__decap_40_12
XFILLER_0_15 VPWR VGND VPWR VGND sky130_ef_sc_hd__decap_40_12
XFILLER_2_189 VGND VGND VPWR VPWR sky130_fd_sc_hd__fill_4
XFILLER_3_3 VGND VGND VPWR VPWR sky130_fd_sc_hd__fill_8
X_189_ rng_rd.mem\[7\]\[0\] net15 VGND VGND VPWR VPWR _079_ sky130_fd_sc_hd__nand2_1
X_327_ rng_dp.inst.next_num_o\[0\] _136_ rng_dp.inst.next_num_o\[1\] VGND VGND VPWR
+ VPWR _165_ sky130_fd_sc_hd__a21oi_1
X_258_ rng_dp.inst.next_num_o\[0\] rng_dp.inst.next_num_o\[2\] VGND VGND VPWR VPWR
+ _142_ sky130_fd_sc_hd__nor2_1
XFILLER_11_222 VGND VGND VPWR VPWR sky130_fd_sc_hd__fill_1
Xfanout9 net11 VGND VGND VPWR VPWR net9 sky130_fd_sc_hd__clkbuf_4
XFILLER_20_89 VGND VGND VPWR VPWR sky130_fd_sc_hd__fill_2
XFILLER_1_80 VGND VGND VPWR VPWR sky130_fd_sc_hd__fill_2
XFILLER_28_141 VPWR VGND VPWR VGND sky130_ef_sc_hd__decap_40_12
Xhold65 rng_rd.mem\[3\]\[0\] VGND VGND VPWR VPWR net92 sky130_fd_sc_hd__dlygate4sd3_1
Xhold32 rng_rd.mem\[1\]\[1\] VGND VGND VPWR VPWR net59 sky130_fd_sc_hd__dlygate4sd3_1
Xhold10 _044_ VGND VGND VPWR VPWR net37 sky130_fd_sc_hd__dlygate4sd3_1
Xhold43 _029_ VGND VGND VPWR VPWR net70 sky130_fd_sc_hd__dlygate4sd3_1
Xhold54 rng_rd.mem\[10\]\[2\] VGND VGND VPWR VPWR net81 sky130_fd_sc_hd__dlygate4sd3_1
Xhold21 _003_ VGND VGND VPWR VPWR net48 sky130_fd_sc_hd__dlygate4sd3_1
XFILLER_31_55 VGND VGND VPWR VPWR sky130_fd_sc_hd__fill_1
XFILLER_25_111 VGND VGND VPWR VPWR sky130_fd_sc_hd__fill_1
XFILLER_16_111 VGND VGND VPWR VPWR sky130_fd_sc_hd__fill_2
XFILLER_15_23 VGND VGND VPWR VPWR sky130_fd_sc_hd__fill_2
XFILLER_0_221 VGND VGND VPWR VPWR sky130_fd_sc_hd__fill_2
XFILLER_31_169 VPWR VGND VPWR VGND sky130_ef_sc_hd__decap_40_12
XFILLER_31_125 VPWR VGND VPWR VGND sky130_ef_sc_hd__decap_40_12
XFILLER_22_136 VGND VGND VPWR VPWR sky130_fd_sc_hd__fill_4
XTAP_TAPCELL_ROW_32_186 VGND VPWR sky130_fd_sc_hd__tapvpwrvgnd_1
XFILLER_26_77 VGND VGND VPWR VPWR sky130_fd_sc_hd__fill_4
XTAP_TAPCELL_ROW_23_153 VGND VPWR sky130_fd_sc_hd__tapvpwrvgnd_1
Xclkbuf_3_3__f_clk_i clknet_0_clk_i VGND VGND VPWR VPWR clknet_3_3__leaf_clk_i sky130_fd_sc_hd__clkbuf_16
X_291_ net54 net56 net10 VGND VGND VPWR VPWR _017_ sky130_fd_sc_hd__mux2_1
X_360_ clknet_3_2__leaf_clk_i _027_ net23 VGND VGND VPWR VPWR rng_rd.mem\[2\]\[0\]
+ sky130_fd_sc_hd__dfrtp_1
XFILLER_13_169 VGND VGND VPWR VPWR sky130_fd_sc_hd__fill_1
XFILLER_13_147 VGND VGND VPWR VPWR sky130_fd_sc_hd__fill_2
XTAP_TAPCELL_ROW_14_120 VGND VPWR sky130_fd_sc_hd__tapvpwrvgnd_1
XFILLER_27_217 VGND VGND VPWR VPWR sky130_fd_sc_hd__fill_4
XPHY_EDGE_ROW_19_Left_53 VGND VGND VPWR VPWR sky130_fd_sc_hd__decap_3
XFILLER_33_209 VPWR VGND VPWR VGND sky130_ef_sc_hd__decap_40_12
XFILLER_18_206 VPWR VGND VPWR VGND sky130_ef_sc_hd__decap_40_12
X_343_ clknet_3_7__leaf_clk_i net55 net25 VGND VGND VPWR VPWR rng_rd.mem\[7\]\[2\]
+ sky130_fd_sc_hd__dfrtp_1
XTAP_TAPCELL_ROW_11_112 VGND VPWR sky130_fd_sc_hd__tapvpwrvgnd_1
X_274_ _140_ _141_ _156_ _155_ _136_ VGND VGND VPWR VPWR _157_ sky130_fd_sc_hd__o311a_1
XFILLER_24_209 VPWR VGND VPWR VGND sky130_ef_sc_hd__decap_40_12
XFILLER_2_124 VPWR VGND VPWR VGND sky130_ef_sc_hd__decap_40_12
XFILLER_0_27 VGND VGND VPWR VPWR sky130_fd_sc_hd__fill_1
XPHY_EDGE_ROW_4_Left_38 VGND VGND VPWR VPWR sky130_fd_sc_hd__decap_3
XFILLER_29_3 VPWR VGND VPWR VGND sky130_ef_sc_hd__decap_40_12
X_188_ _073_ _074_ _077_ VGND VGND VPWR VPWR _078_ sky130_fd_sc_hd__and3_1
XTAP_TAPCELL_ROW_0_70 VGND VPWR sky130_fd_sc_hd__tapvpwrvgnd_1
X_326_ rng_dp.inst.next_num_o\[0\] rng_dp.inst.next_num_o\[1\] _136_ VGND VGND VPWR
+ VPWR _164_ sky130_fd_sc_hd__and3_1
X_257_ rng_dp.inst.next_num_o\[0\] _066_ VGND VGND VPWR VPWR _141_ sky130_fd_sc_hd__nor2_1
X_309_ net94 net17 net8 VGND VGND VPWR VPWR _035_ sky130_fd_sc_hd__mux2_1
XFILLER_29_109 VGND VGND VPWR VPWR sky130_fd_sc_hd__fill_2
XFILLER_29_55 VGND VGND VPWR VPWR sky130_fd_sc_hd__fill_1
XFILLER_28_197 VPWR VGND VPWR VGND sky130_ef_sc_hd__decap_40_12
XFILLER_28_153 VPWR VGND VPWR VGND sky130_ef_sc_hd__decap_40_12
Xhold22 rng_rd.vld\[4\] VGND VGND VPWR VPWR net49 sky130_fd_sc_hd__dlygate4sd3_1
Xhold44 rng_rd.mem\[6\]\[1\] VGND VGND VPWR VPWR net71 sky130_fd_sc_hd__dlygate4sd3_1
Xhold55 rng_rd.mem\[6\]\[0\] VGND VGND VPWR VPWR net82 sky130_fd_sc_hd__dlygate4sd3_1
Xhold66 _021_ VGND VGND VPWR VPWR net93 sky130_fd_sc_hd__dlygate4sd3_1
Xhold33 rng_rd.mem\[8\]\[2\] VGND VGND VPWR VPWR net60 sky130_fd_sc_hd__dlygate4sd3_1
XPHY_EDGE_ROW_7_Left_41 VGND VGND VPWR VPWR sky130_fd_sc_hd__decap_3
Xhold11 rng_rd.vld\[10\] VGND VGND VPWR VPWR net38 sky130_fd_sc_hd__dlygate4sd3_1
XPHY_EDGE_ROW_33_Left_67 VGND VGND VPWR VPWR sky130_fd_sc_hd__decap_3
XFILLER_25_167 VGND VGND VPWR VPWR sky130_fd_sc_hd__fill_1
XFILLER_15_57 VGND VGND VPWR VPWR sky130_fd_sc_hd__fill_1
XFILLER_15_46 VGND VGND VPWR VPWR sky130_fd_sc_hd__fill_1
XFILLER_15_13 VGND VGND VPWR VPWR sky130_fd_sc_hd__fill_1
XFILLER_31_137 VPWR VGND VPWR VGND sky130_ef_sc_hd__decap_40_12
XTAP_TAPCELL_ROW_26_162 VGND VPWR sky130_fd_sc_hd__tapvpwrvgnd_1
XFILLER_16_123 VPWR VGND VPWR VGND sky130_ef_sc_hd__decap_40_12
XFILLER_16_101 VGND VGND VPWR VPWR sky130_fd_sc_hd__fill_1
XFILLER_11_3 VGND VGND VPWR VPWR sky130_fd_sc_hd__fill_2
XFILLER_13_104 VGND VGND VPWR VPWR sky130_fd_sc_hd__fill_1
XTAP_TAPCELL_ROW_23_154 VGND VPWR sky130_fd_sc_hd__tapvpwrvgnd_1
X_290_ net71 rng_rd.mem\[5\]\[1\] net10 VGND VGND VPWR VPWR _016_ sky130_fd_sc_hd__mux2_1
XFILLER_13_159 VGND VGND VPWR VPWR sky130_fd_sc_hd__fill_8
XTAP_TAPCELL_ROW_14_121 VGND VPWR sky130_fd_sc_hd__tapvpwrvgnd_1
X_342_ clknet_3_7__leaf_clk_i _010_ net25 VGND VGND VPWR VPWR rng_rd.mem\[7\]\[1\]
+ sky130_fd_sc_hd__dfrtp_1
XFILLER_18_218 VGND VGND VPWR VPWR sky130_fd_sc_hd__fill_4
X_273_ rng_dp.seed_sel_i\[1\] rng_dp.seed_sel_i\[0\] VGND VGND VPWR VPWR _156_ sky130_fd_sc_hd__nand2_1
XFILLER_32_221 VGND VGND VPWR VPWR sky130_fd_sc_hd__fill_2
XPHY_EDGE_ROW_20_Left_54 VGND VGND VPWR VPWR sky130_fd_sc_hd__decap_3
XFILLER_5_166 VGND VGND VPWR VPWR sky130_fd_sc_hd__fill_2
XFILLER_23_221 VGND VGND VPWR VPWR sky130_fd_sc_hd__fill_2
XFILLER_23_57 VPWR VGND VPWR VGND sky130_ef_sc_hd__decap_40_12
XFILLER_2_136 VGND VGND VPWR VPWR sky130_fd_sc_hd__fill_4
XFILLER_4_81 VGND VGND VPWR VPWR sky130_fd_sc_hd__fill_2
X_187_ num_i_bar\[0\] _070_ _075_ _076_ rng_rd.vld\[4\] VGND VGND VPWR VPWR _077_
+ sky130_fd_sc_hd__o221a_1
XFILLER_14_221 VGND VGND VPWR VPWR sky130_fd_sc_hd__fill_2
XTAP_TAPCELL_ROW_0_71 VGND VPWR sky130_fd_sc_hd__tapvpwrvgnd_1
X_325_ _064_ _136_ VGND VGND VPWR VPWR _051_ sky130_fd_sc_hd__xnor2_1
X_256_ _065_ rng_dp.inst.next_num_o\[1\] VGND VGND VPWR VPWR _140_ sky130_fd_sc_hd__nor2_1
Xclkload0 clknet_3_0__leaf_clk_i VGND VGND VPWR VPWR clkload0/X sky130_fd_sc_hd__clkbuf_4
X_239_ _060_ rng_rd.mem\[5\]\[2\] rng_rd.mem\[5\]\[0\] net15 VGND VGND VPWR VPWR _129_
+ sky130_fd_sc_hd__o2bb2a_1
X_308_ net95 net18 net8 VGND VGND VPWR VPWR _034_ sky130_fd_sc_hd__mux2_1
XFILLER_28_165 VPWR VGND VPWR VGND sky130_ef_sc_hd__decap_40_12
XFILLER_28_121 VPWR VGND VPWR VGND sky130_ef_sc_hd__decap_40_12
Xhold45 _016_ VGND VGND VPWR VPWR net72 sky130_fd_sc_hd__dlygate4sd3_1
Xhold23 rng_rd.vld\[2\] VGND VGND VPWR VPWR net50 sky130_fd_sc_hd__dlygate4sd3_1
Xhold56 _015_ VGND VGND VPWR VPWR net83 sky130_fd_sc_hd__dlygate4sd3_1
Xhold34 _050_ VGND VGND VPWR VPWR net61 sky130_fd_sc_hd__dlygate4sd3_1
Xhold67 net6 VGND VGND VPWR VPWR net94 sky130_fd_sc_hd__dlygate4sd3_1
XFILLER_4_209 VPWR VGND VPWR VGND sky130_ef_sc_hd__decap_40_12
Xhold12 _046_ VGND VGND VPWR VPWR net39 sky130_fd_sc_hd__dlygate4sd3_1
XFILLER_13_7 VGND VGND VPWR VPWR sky130_fd_sc_hd__fill_2
XTAP_TAPCELL_ROW_6_92 VGND VPWR sky130_fd_sc_hd__tapvpwrvgnd_1
XFILLER_31_57 VPWR VGND VPWR VGND sky130_ef_sc_hd__decap_40_12
XFILLER_25_113 VPWR VGND VPWR VGND sky130_ef_sc_hd__decap_40_12
XFILLER_15_25 VGND VGND VPWR VPWR sky130_fd_sc_hd__fill_1
XFILLER_31_149 VPWR VGND VPWR VGND sky130_ef_sc_hd__decap_40_12
XFILLER_31_105 VGND VGND VPWR VPWR sky130_fd_sc_hd__fill_4
XPHY_EDGE_ROW_28_Right_28 VGND VGND VPWR VPWR sky130_fd_sc_hd__decap_3
XTAP_TAPCELL_ROW_26_163 VGND VPWR sky130_fd_sc_hd__tapvpwrvgnd_1
XPHY_EDGE_ROW_19_Right_19 VGND VGND VPWR VPWR sky130_fd_sc_hd__decap_3
XFILLER_16_135 VGND VGND VPWR VPWR sky130_fd_sc_hd__fill_4
XFILLER_30_193 VGND VGND VPWR VPWR sky130_fd_sc_hd__fill_2
XFILLER_13_149 VGND VGND VPWR VPWR sky130_fd_sc_hd__fill_1
XTAP_TAPCELL_ROW_14_122 VGND VPWR sky130_fd_sc_hd__tapvpwrvgnd_1
XFILLER_12_193 VGND VGND VPWR VPWR sky130_fd_sc_hd__fill_2
XTAP_TAPCELL_ROW_3_82 VGND VPWR sky130_fd_sc_hd__tapvpwrvgnd_1
XFILLER_8_131 VGND VGND VPWR VPWR sky130_fd_sc_hd__fill_8
X_341_ clknet_3_7__leaf_clk_i net67 net25 VGND VGND VPWR VPWR rng_rd.mem\[7\]\[0\]
+ sky130_fd_sc_hd__dfrtp_1
X_272_ rng_dp.inst.next_num_o\[0\] _066_ _137_ _154_ VGND VGND VPWR VPWR _155_ sky130_fd_sc_hd__a211o_1
XFILLER_23_69 VGND VGND VPWR VPWR sky130_fd_sc_hd__fill_8
X_186_ net16 rng_rd.mem\[4\]\[2\] VGND VGND VPWR VPWR _076_ sky130_fd_sc_hd__nor2_1
X_324_ net60 rng_rd.mem\[7\]\[2\] net9 VGND VGND VPWR VPWR _050_ sky130_fd_sc_hd__mux2_1
XFILLER_0_29 VPWR VGND VPWR VGND sky130_ef_sc_hd__decap_40_12
X_255_ net52 rng_rd.mem\[10\]\[2\] net8 VGND VGND VPWR VPWR _005_ sky130_fd_sc_hd__mux2_1
XFILLER_1_181 VPWR VGND VPWR VGND sky130_ef_sc_hd__decap_40_12
XTAP_TAPCELL_ROW_0_72 VGND VPWR sky130_fd_sc_hd__tapvpwrvgnd_1
XFILLER_1_3 VGND VGND VPWR VPWR sky130_fd_sc_hd__fill_1
Xclkload1 clknet_3_1__leaf_clk_i VGND VGND VPWR VPWR clkload1/X sky130_fd_sc_hd__clkbuf_8
X_307_ net89 num_i_bar\[0\] net7 VGND VGND VPWR VPWR _033_ sky130_fd_sc_hd__mux2_1
X_238_ _126_ _127_ _123_ VGND VGND VPWR VPWR _128_ sky130_fd_sc_hd__and3b_1
X_169_ net16 VGND VGND VPWR VPWR _060_ sky130_fd_sc_hd__inv_2
XFILLER_29_57 VPWR VGND VPWR VGND sky130_ef_sc_hd__decap_40_12
XFILLER_28_177 VPWR VGND VPWR VGND sky130_ef_sc_hd__decap_40_12
XFILLER_28_133 VGND VGND VPWR VPWR sky130_fd_sc_hd__fill_4
Xhold24 rng_rd.vld\[5\] VGND VGND VPWR VPWR net51 sky130_fd_sc_hd__dlygate4sd3_1
Xhold46 rng_rd.mem\[5\]\[1\] VGND VGND VPWR VPWR net73 sky130_fd_sc_hd__dlygate4sd3_1
Xhold13 rng_rd.vld\[1\] VGND VGND VPWR VPWR net40 sky130_fd_sc_hd__dlygate4sd3_1
Xhold35 rng_rd.mem\[2\]\[1\] VGND VGND VPWR VPWR net62 sky130_fd_sc_hd__dlygate4sd3_1
XFILLER_20_26 VGND VGND VPWR VPWR sky130_fd_sc_hd__fill_2
XFILLER_20_15 VGND VGND VPWR VPWR sky130_fd_sc_hd__fill_2
Xhold68 net5 VGND VGND VPWR VPWR net95 sky130_fd_sc_hd__dlygate4sd3_1
Xhold57 rng_rd.mem\[9\]\[0\] VGND VGND VPWR VPWR net84 sky130_fd_sc_hd__dlygate4sd3_1
XFILLER_19_111 VGND VGND VPWR VPWR sky130_fd_sc_hd__fill_1
XFILLER_19_90 VGND VGND VPWR VPWR sky130_fd_sc_hd__fill_4
XFILLER_3_221 VGND VGND VPWR VPWR sky130_fd_sc_hd__fill_2
XTAP_TAPCELL_ROW_6_93 VGND VPWR sky130_fd_sc_hd__tapvpwrvgnd_1
XFILLER_25_169 VPWR VGND VPWR VGND sky130_ef_sc_hd__decap_40_12
XFILLER_25_125 VPWR VGND VPWR VGND sky130_ef_sc_hd__decap_40_12
XFILLER_31_69 VPWR VGND VPWR VGND sky130_ef_sc_hd__decap_40_12
XTAP_TAPCELL_ROW_26_164 VGND VPWR sky130_fd_sc_hd__tapvpwrvgnd_1
XTAP_TAPCELL_ROW_17_131 VGND VPWR sky130_fd_sc_hd__tapvpwrvgnd_1
XFILLER_11_5 VGND VGND VPWR VPWR sky130_fd_sc_hd__fill_1
XTAP_TAPCELL_ROW_14_123 VGND VPWR sky130_fd_sc_hd__tapvpwrvgnd_1
XFILLER_12_161 VGND VGND VPWR VPWR sky130_fd_sc_hd__fill_8
XTAP_TAPCELL_ROW_3_83 VGND VPWR sky130_fd_sc_hd__tapvpwrvgnd_1
XFILLER_12_49 VGND VGND VPWR VPWR sky130_fd_sc_hd__fill_1
X_340_ clknet_3_0__leaf_clk_i _002_ net20 VGND VGND VPWR VPWR rng_dp.seed_sel_i\[1\]
+ sky130_fd_sc_hd__dfrtp_2
X_271_ rng_dp.inst.next_num_o\[2\] _141_ VGND VGND VPWR VPWR _154_ sky130_fd_sc_hd__nor2_1
XFILLER_23_201 VPWR VGND VPWR VGND sky130_ef_sc_hd__decap_40_12
XFILLER_23_15 VPWR VGND VPWR VGND sky130_ef_sc_hd__decap_40_12
XFILLER_4_83 VGND VGND VPWR VPWR sky130_fd_sc_hd__fill_1
X_323_ net91 rng_rd.mem\[7\]\[1\] net10 VGND VGND VPWR VPWR _049_ sky130_fd_sc_hd__mux2_1
X_185_ net16 rng_rd.mem\[4\]\[2\] VGND VGND VPWR VPWR _075_ sky130_fd_sc_hd__and2_1
X_254_ net33 net96 net8 VGND VGND VPWR VPWR _004_ sky130_fd_sc_hd__mux2_1
XFILLER_1_193 VPWR VGND VPWR VGND sky130_ef_sc_hd__decap_40_12
XTAP_TAPCELL_ROW_0_73 VGND VPWR sky130_fd_sc_hd__tapvpwrvgnd_1
Xclkload2 clknet_3_3__leaf_clk_i VGND VGND VPWR VPWR clkload2/X sky130_fd_sc_hd__clkbuf_4
XFILLER_18_59 VPWR VGND VPWR VGND sky130_ef_sc_hd__decap_40_12
XFILLER_18_26 VGND VGND VPWR VPWR sky130_fd_sc_hd__fill_2
XFILLER_11_204 VPWR VGND VPWR VGND sky130_ef_sc_hd__decap_40_12
XFILLER_27_3 VPWR VGND VPWR VGND sky130_ef_sc_hd__decap_40_12
X_237_ _059_ rng_rd.mem\[8\]\[1\] _124_ _125_ rng_rd.vld\[8\] VGND VGND VPWR VPWR
+ _127_ sky130_fd_sc_hd__o221a_1
X_168_ net18 VGND VGND VPWR VPWR _059_ sky130_fd_sc_hd__inv_2
X_306_ net78 net6 net8 VGND VGND VPWR VPWR _032_ sky130_fd_sc_hd__mux2_1
XFILLER_29_69 VPWR VGND VPWR VGND sky130_ef_sc_hd__decap_40_12
Xhold14 rng_rd.vld\[6\] VGND VGND VPWR VPWR net41 sky130_fd_sc_hd__dlygate4sd3_1
Xhold47 _019_ VGND VGND VPWR VPWR net74 sky130_fd_sc_hd__dlygate4sd3_1
Xhold58 _012_ VGND VGND VPWR VPWR net85 sky130_fd_sc_hd__dlygate4sd3_1
Xhold25 rng_rd.mem\[11\]\[2\] VGND VGND VPWR VPWR net52 sky130_fd_sc_hd__dlygate4sd3_1
Xhold69 rng_rd.mem\[10\]\[1\] VGND VGND VPWR VPWR net96 sky130_fd_sc_hd__dlygate4sd3_1
Xhold36 rng_rd.mem\[9\]\[2\] VGND VGND VPWR VPWR net63 sky130_fd_sc_hd__dlygate4sd3_1
XTAP_TAPCELL_ROW_29_173 VGND VPWR sky130_fd_sc_hd__tapvpwrvgnd_1
XFILLER_28_189 VGND VGND VPWR VPWR sky130_fd_sc_hd__fill_4
Xclkbuf_3_6__f_clk_i clknet_0_clk_i VGND VGND VPWR VPWR clknet_3_6__leaf_clk_i sky130_fd_sc_hd__clkbuf_16
XFILLER_13_9 VGND VGND VPWR VPWR sky130_fd_sc_hd__fill_1
XFILLER_33_181 VPWR VGND VPWR VGND sky130_ef_sc_hd__decap_40_12
XFILLER_25_137 VPWR VGND VPWR VGND sky130_ef_sc_hd__decap_40_12
XTAP_TAPCELL_ROW_6_94 VGND VPWR sky130_fd_sc_hd__tapvpwrvgnd_1
XFILLER_31_15 VPWR VGND VPWR VGND sky130_ef_sc_hd__decap_40_12
XTAP_TAPCELL_ROW_26_165 VGND VPWR sky130_fd_sc_hd__tapvpwrvgnd_1
XPHY_EDGE_ROW_1_Right_1 VGND VGND VPWR VPWR sky130_fd_sc_hd__decap_3
XFILLER_30_195 VGND VGND VPWR VPWR sky130_fd_sc_hd__fill_1
XTAP_TAPCELL_ROW_17_132 VGND VPWR sky130_fd_sc_hd__tapvpwrvgnd_1
XFILLER_7_61 VGND VGND VPWR VPWR sky130_fd_sc_hd__fill_1
XFILLER_26_15 VPWR VGND VPWR VGND sky130_ef_sc_hd__decap_40_12
XFILLER_21_162 VGND VGND VPWR VPWR sky130_fd_sc_hd__fill_4
XFILLER_21_151 VGND VGND VPWR VPWR sky130_fd_sc_hd__fill_2
XTAP_TAPCELL_ROW_8_100 VGND VPWR sky130_fd_sc_hd__tapvpwrvgnd_1
XFILLER_12_195 VGND VGND VPWR VPWR sky130_fd_sc_hd__fill_1
XTAP_TAPCELL_ROW_3_84 VGND VPWR sky130_fd_sc_hd__tapvpwrvgnd_1
XFILLER_8_144 VGND VGND VPWR VPWR sky130_fd_sc_hd__fill_2
XFILLER_26_221 VGND VGND VPWR VPWR sky130_fd_sc_hd__fill_2
XFILLER_17_221 VGND VGND VPWR VPWR sky130_fd_sc_hd__fill_2
X_270_ _065_ rng_dp.inst.next_num_o\[1\] _148_ _152_ VGND VGND VPWR VPWR _153_ sky130_fd_sc_hd__a22o_1
XFILLER_5_169 VGND VGND VPWR VPWR sky130_fd_sc_hd__fill_4
XFILLER_23_213 VGND VGND VPWR VPWR sky130_fd_sc_hd__fill_8
XFILLER_23_27 VPWR VGND VPWR VGND sky130_ef_sc_hd__decap_40_12
X_322_ net77 net66 net10 VGND VGND VPWR VPWR _048_ sky130_fd_sc_hd__mux2_1
XPHY_EDGE_ROW_24_Left_58 VGND VGND VPWR VPWR sky130_fd_sc_hd__decap_3
X_184_ net14 rng_rd.mem\[4\]\[0\] rng_rd.mem\[4\]\[1\] net13 VGND VGND VPWR VPWR _074_
+ sky130_fd_sc_hd__o22a_1
XTAP_TAPCELL_ROW_0_74 VGND VPWR sky130_fd_sc_hd__tapvpwrvgnd_1
XFILLER_1_161 VGND VGND VPWR VPWR sky130_fd_sc_hd__fill_4
X_253_ net47 rng_rd.mem\[10\]\[0\] net9 VGND VGND VPWR VPWR _003_ sky130_fd_sc_hd__mux2_1
XFILLER_11_216 VGND VGND VPWR VPWR sky130_fd_sc_hd__fill_4
Xclkload3 clknet_3_4__leaf_clk_i VGND VGND VPWR VPWR clkload3/Y sky130_fd_sc_hd__clkinv_2
XFILLER_24_81 VGND VGND VPWR VPWR sky130_fd_sc_hd__fill_2
X_167_ rng_rd.mem\[7\]\[1\] VGND VGND VPWR VPWR _058_ sky130_fd_sc_hd__inv_2
X_236_ net15 rng_rd.mem\[8\]\[0\] rng_rd.mem\[8\]\[1\] _059_ VGND VGND VPWR VPWR _126_
+ sky130_fd_sc_hd__a22o_1
X_305_ net59 net5 net7 VGND VGND VPWR VPWR _031_ sky130_fd_sc_hd__mux2_1
XFILLER_29_15 VPWR VGND VPWR VGND sky130_ef_sc_hd__decap_40_12
Xhold15 _042_ VGND VGND VPWR VPWR net42 sky130_fd_sc_hd__dlygate4sd3_1
XFILLER_19_113 VGND VGND VPWR VPWR sky130_fd_sc_hd__fill_4
Xhold48 rng_rd.mem\[2\]\[0\] VGND VGND VPWR VPWR net75 sky130_fd_sc_hd__dlygate4sd3_1
Xhold37 rng_rd.mem\[3\]\[2\] VGND VGND VPWR VPWR net64 sky130_fd_sc_hd__dlygate4sd3_1
Xhold59 rng_rd.mem\[9\]\[1\] VGND VGND VPWR VPWR net86 sky130_fd_sc_hd__dlygate4sd3_1
Xhold26 _005_ VGND VGND VPWR VPWR net53 sky130_fd_sc_hd__dlygate4sd3_1
XFILLER_10_50 VGND VGND VPWR VPWR sky130_fd_sc_hd__fill_2
XTAP_TAPCELL_ROW_29_174 VGND VPWR sky130_fd_sc_hd__tapvpwrvgnd_1
XPHY_EDGE_ROW_27_Left_61 VGND VGND VPWR VPWR sky130_fd_sc_hd__decap_3
XFILLER_25_105 VGND VGND VPWR VPWR sky130_fd_sc_hd__fill_4
XPHY_EDGE_ROW_11_Left_45 VGND VGND VPWR VPWR sky130_fd_sc_hd__decap_3
XTAP_TAPCELL_ROW_6_95 VGND VPWR sky130_fd_sc_hd__tapvpwrvgnd_1
X_219_ net16 rng_rd.mem\[9\]\[2\] VGND VGND VPWR VPWR _109_ sky130_fd_sc_hd__xor2_1
XFILLER_33_193 VGND VGND VPWR VPWR sky130_fd_sc_hd__fill_2
XFILLER_31_27 VPWR VGND VPWR VGND sky130_ef_sc_hd__decap_40_12
XFILLER_25_149 VPWR VGND VPWR VGND sky130_ef_sc_hd__decap_40_12
XFILLER_24_193 VGND VGND VPWR VPWR sky130_fd_sc_hd__fill_2
XTAP_TAPCELL_ROW_17_133 VGND VPWR sky130_fd_sc_hd__tapvpwrvgnd_1
XFILLER_30_141 VPWR VGND VPWR VGND sky130_ef_sc_hd__decap_40_12
XFILLER_26_27 VGND VGND VPWR VPWR sky130_fd_sc_hd__fill_1
XPHY_EDGE_ROW_24_Right_24 VGND VGND VPWR VPWR sky130_fd_sc_hd__decap_3
XPHY_EDGE_ROW_15_Right_15 VGND VGND VPWR VPWR sky130_fd_sc_hd__decap_3
XPHY_EDGE_ROW_33_Right_33 VGND VGND VPWR VPWR sky130_fd_sc_hd__decap_3
XFILLER_32_81 VGND VGND VPWR VPWR sky130_fd_sc_hd__fill_2
XTAP_TAPCELL_ROW_31_180 VGND VPWR sky130_fd_sc_hd__tapvpwrvgnd_1
XFILLER_12_141 VPWR VGND VPWR VGND sky130_ef_sc_hd__decap_40_12
XFILLER_12_130 VGND VGND VPWR VPWR sky130_fd_sc_hd__fill_8
XTAP_TAPCELL_ROW_8_101 VGND VPWR sky130_fd_sc_hd__tapvpwrvgnd_1
XFILLER_27_81 VPWR VGND VPWR VGND sky130_ef_sc_hd__decap_40_12
XFILLER_4_41 VGND VGND VPWR VPWR sky130_fd_sc_hd__fill_4
XFILLER_4_85 VGND VGND VPWR VPWR sky130_fd_sc_hd__fill_4
XFILLER_23_39 VPWR VGND VPWR VGND sky130_ef_sc_hd__decap_40_12
X_183_ net13 rng_rd.mem\[4\]\[1\] VGND VGND VPWR VPWR _073_ sky130_fd_sc_hd__nand2_1
X_252_ rng_rd.wr_pulse _095_ _113_ _134_ VGND VGND VPWR VPWR _139_ sky130_fd_sc_hd__and4_1
X_321_ net34 rng_rd.vld\[10\] net9 VGND VGND VPWR VPWR _047_ sky130_fd_sc_hd__mux2_1
X_304_ net80 net89 net7 VGND VGND VPWR VPWR _030_ sky130_fd_sc_hd__mux2_1
X_235_ net17 rng_rd.mem\[8\]\[2\] VGND VGND VPWR VPWR _125_ sky130_fd_sc_hd__and2_1
Xclkload4 clknet_3_5__leaf_clk_i VGND VGND VPWR VPWR clkload4/X sky130_fd_sc_hd__clkbuf_4
XFILLER_20_29 VGND VGND VPWR VPWR sky130_fd_sc_hd__fill_2
XFILLER_1_53 VGND VGND VPWR VPWR sky130_fd_sc_hd__fill_2
XFILLER_1_42 VGND VGND VPWR VPWR sky130_fd_sc_hd__fill_1
XFILLER_6_221 VGND VGND VPWR VPWR sky130_fd_sc_hd__fill_2
X_166_ num_i_bar\[0\] VGND VGND VPWR VPWR _057_ sky130_fd_sc_hd__inv_2
XFILLER_29_27 VPWR VGND VPWR VGND sky130_ef_sc_hd__decap_40_12
Xhold16 rng_rd.vld\[7\] VGND VGND VPWR VPWR net43 sky130_fd_sc_hd__dlygate4sd3_1
Xhold49 _024_ VGND VGND VPWR VPWR net76 sky130_fd_sc_hd__dlygate4sd3_1
Xhold27 rng_rd.mem\[6\]\[2\] VGND VGND VPWR VPWR net54 sky130_fd_sc_hd__dlygate4sd3_1
Xhold38 _026_ VGND VGND VPWR VPWR net65 sky130_fd_sc_hd__dlygate4sd3_1
XFILLER_32_3 VPWR VGND VPWR VGND sky130_ef_sc_hd__decap_40_12
XTAP_TAPCELL_ROW_29_175 VGND VPWR sky130_fd_sc_hd__tapvpwrvgnd_1
XFILLER_19_71 VGND VGND VPWR VPWR sky130_fd_sc_hd__fill_4
X_218_ _105_ _106_ _107_ VGND VGND VPWR VPWR _108_ sky130_fd_sc_hd__or3b_1
XFILLER_31_39 VPWR VGND VPWR VGND sky130_ef_sc_hd__decap_40_12
XFILLER_18_180 VGND VGND VPWR VPWR sky130_fd_sc_hd__fill_2
XFILLER_31_109 VGND VGND VPWR VPWR sky130_fd_sc_hd__fill_2
XFILLER_16_139 VGND VGND VPWR VPWR sky130_fd_sc_hd__fill_1
XFILLER_30_197 VPWR VGND VPWR VGND sky130_ef_sc_hd__decap_40_12
XFILLER_30_153 VPWR VGND VPWR VGND sky130_ef_sc_hd__decap_40_12
XFILLER_7_41 VPWR VGND VPWR VGND sky130_ef_sc_hd__decap_40_12
XTAP_TAPCELL_ROW_31_181 VGND VPWR sky130_fd_sc_hd__tapvpwrvgnd_1
XTAP_TAPCELL_ROW_8_102 VGND VPWR sky130_fd_sc_hd__tapvpwrvgnd_1
XFILLER_8_124 VGND VGND VPWR VPWR sky130_fd_sc_hd__fill_4
XFILLER_8_146 VGND VGND VPWR VPWR sky130_fd_sc_hd__fill_1
XFILLER_27_93 VPWR VGND VPWR VGND sky130_ef_sc_hd__decap_40_12
XFILLER_4_171 VPWR VGND VPWR VGND sky130_ef_sc_hd__decap_40_12
XFILLER_4_64 VGND VGND VPWR VPWR sky130_fd_sc_hd__fill_2
XFILLER_4_97 VGND VGND VPWR VPWR sky130_fd_sc_hd__fill_4
X_182_ rng_rd.mem\[6\]\[1\] VGND VGND VPWR VPWR _072_ sky130_fd_sc_hd__inv_2
X_251_ _137_ _138_ VGND VGND VPWR VPWR _002_ sky130_fd_sc_hd__nand2_1
X_320_ net38 rng_rd.vld\[9\] net9 VGND VGND VPWR VPWR _046_ sky130_fd_sc_hd__mux2_1
XFILLER_18_29 VGND VGND VPWR VPWR sky130_fd_sc_hd__fill_2
Xclkload5 clknet_3_6__leaf_clk_i VGND VGND VPWR VPWR clkload5/Y sky130_fd_sc_hd__clkinv_2
XFILLER_24_83 VGND VGND VPWR VPWR sky130_fd_sc_hd__fill_1
X_303_ net69 rng_rd.mem\[1\]\[2\] net8 VGND VGND VPWR VPWR _029_ sky130_fd_sc_hd__mux2_1
X_234_ net16 rng_rd.mem\[8\]\[2\] VGND VGND VPWR VPWR _124_ sky130_fd_sc_hd__nor2_1
XFILLER_29_39 VPWR VGND VPWR VGND sky130_ef_sc_hd__decap_40_12
XFILLER_28_137 VGND VGND VPWR VPWR sky130_fd_sc_hd__fill_2
Xhold39 rng_rd.mem\[7\]\[0\] VGND VGND VPWR VPWR net66 sky130_fd_sc_hd__dlygate4sd3_1
Xhold28 _011_ VGND VGND VPWR VPWR net55 sky130_fd_sc_hd__dlygate4sd3_1
Xhold17 rng_rd.vld\[9\] VGND VGND VPWR VPWR net44 sky130_fd_sc_hd__dlygate4sd3_1
XFILLER_27_181 VPWR VGND VPWR VGND sky130_ef_sc_hd__decap_40_12
XFILLER_19_104 VGND VGND VPWR VPWR sky130_fd_sc_hd__fill_1
XFILLER_19_94 VGND VGND VPWR VPWR sky130_fd_sc_hd__fill_2
XFILLER_19_61 VGND VGND VPWR VPWR sky130_fd_sc_hd__fill_2
XFILLER_19_50 VGND VGND VPWR VPWR sky130_fd_sc_hd__fill_4
X_217_ net14 rng_rd.mem\[6\]\[0\] _072_ net19 rng_rd.vld\[6\] VGND VGND VPWR VPWR
+ _107_ sky130_fd_sc_hd__o221a_1
XFILLER_10_85 VGND VGND VPWR VPWR sky130_fd_sc_hd__fill_1
XFILLER_10_52 VGND VGND VPWR VPWR sky130_fd_sc_hd__fill_1
XFILLER_33_195 VGND VGND VPWR VPWR sky130_fd_sc_hd__fill_1
XFILLER_25_3 VPWR VGND VPWR VGND sky130_ef_sc_hd__decap_40_12
XFILLER_18_192 VGND VGND VPWR VPWR sky130_fd_sc_hd__fill_4
XFILLER_24_195 VGND VGND VPWR VPWR sky130_fd_sc_hd__fill_1
XFILLER_30_165 VPWR VGND VPWR VGND sky130_ef_sc_hd__decap_40_12
XFILLER_30_121 VPWR VGND VPWR VGND sky130_ef_sc_hd__decap_40_12
XFILLER_7_53 VGND VGND VPWR VPWR sky130_fd_sc_hd__fill_2
XTAP_TAPCELL_ROW_31_182 VGND VPWR sky130_fd_sc_hd__tapvpwrvgnd_1
XFILLER_29_221 VGND VGND VPWR VPWR sky130_fd_sc_hd__fill_2
XFILLER_26_29 VPWR VGND VPWR VGND sky130_ef_sc_hd__decap_40_12
XPHY_EDGE_ROW_5_Right_5 VGND VGND VPWR VPWR sky130_fd_sc_hd__decap_3
XFILLER_32_83 VGND VGND VPWR VPWR sky130_fd_sc_hd__fill_1
XFILLER_4_183 VPWR VGND VPWR VGND sky130_ef_sc_hd__decap_40_12
X_181_ rng_rd.mem\[5\]\[0\] VGND VGND VPWR VPWR _071_ sky130_fd_sc_hd__inv_2
XFILLER_13_41 VGND VGND VPWR VPWR sky130_fd_sc_hd__fill_4
X_250_ rng_dp.seed_sel_i\[1\] _001_ VGND VGND VPWR VPWR _138_ sky130_fd_sc_hd__nand2_1
Xfanout20 net27 VGND VGND VPWR VPWR net20 sky130_fd_sc_hd__clkbuf_4
X_379_ clknet_3_5__leaf_clk_i _045_ net24 VGND VGND VPWR VPWR rng_rd.vld\[9\] sky130_fd_sc_hd__dfrtp_1
XFILLER_9_220 VGND VGND VPWR VPWR sky130_fd_sc_hd__fill_2
Xclkload6 clknet_3_7__leaf_clk_i VGND VGND VPWR VPWR clkload6/X sky130_fd_sc_hd__clkbuf_8
X_302_ net62 net59 net7 VGND VGND VPWR VPWR _028_ sky130_fd_sc_hd__mux2_1
X_233_ net15 rng_rd.mem\[8\]\[0\] VGND VGND VPWR VPWR _123_ sky130_fd_sc_hd__or2_1
XFILLER_1_55 VGND VGND VPWR VPWR sky130_fd_sc_hd__fill_1
Xhold18 rng_rd.vld\[3\] VGND VGND VPWR VPWR net45 sky130_fd_sc_hd__dlygate4sd3_1
Xhold29 rng_rd.mem\[5\]\[2\] VGND VGND VPWR VPWR net56 sky130_fd_sc_hd__dlygate4sd3_1
XFILLER_27_193 VPWR VGND VPWR VGND sky130_ef_sc_hd__decap_40_12
XFILLER_33_141 VPWR VGND VPWR VGND sky130_ef_sc_hd__decap_40_12
XFILLER_18_182 VGND VGND VPWR VPWR sky130_fd_sc_hd__fill_1
XFILLER_18_3 VGND VGND VPWR VPWR sky130_fd_sc_hd__fill_2
X_216_ net14 rng_rd.mem\[6\]\[0\] _072_ net19 VGND VGND VPWR VPWR _106_ sky130_fd_sc_hd__a22o_1
XFILLER_24_141 VPWR VGND VPWR VGND sky130_ef_sc_hd__decap_40_12
XFILLER_30_177 VPWR VGND VPWR VGND sky130_ef_sc_hd__decap_40_12
XFILLER_30_133 VGND VGND VPWR VPWR sky130_fd_sc_hd__fill_4
XFILLER_15_130 VGND VGND VPWR VPWR sky130_fd_sc_hd__fill_1
XPHY_EDGE_ROW_15_Left_49 VGND VGND VPWR VPWR sky130_fd_sc_hd__decap_3
XFILLER_21_166 VGND VGND VPWR VPWR sky130_fd_sc_hd__fill_2
XTAP_TAPCELL_ROW_22_150 VGND VPWR sky130_fd_sc_hd__tapvpwrvgnd_1
XPHY_EDGE_ROW_20_Right_20 VGND VGND VPWR VPWR sky130_fd_sc_hd__decap_3
XFILLER_16_74 VGND VGND VPWR VPWR sky130_fd_sc_hd__fill_1
XPHY_EDGE_ROW_11_Right_11 VGND VGND VPWR VPWR sky130_fd_sc_hd__decap_3
XFILLER_27_51 VGND VGND VPWR VPWR sky130_fd_sc_hd__fill_4
XFILLER_4_77 VGND VGND VPWR VPWR sky130_fd_sc_hd__fill_4
XFILLER_4_195 VGND VGND VPWR VPWR sky130_fd_sc_hd__fill_1
XPHY_EDGE_ROW_18_Left_52 VGND VGND VPWR VPWR sky130_fd_sc_hd__decap_3
X_180_ rng_rd.mem\[4\]\[0\] VGND VGND VPWR VPWR _070_ sky130_fd_sc_hd__inv_2
Xfanout10 net11 VGND VGND VPWR VPWR net10 sky130_fd_sc_hd__clkbuf_4
Xfanout21 net27 VGND VGND VPWR VPWR net21 sky130_fd_sc_hd__buf_2
XFILLER_20_209 VPWR VGND VPWR VGND sky130_ef_sc_hd__decap_40_12
X_378_ clknet_3_5__leaf_clk_i net37 net24 VGND VGND VPWR VPWR rng_rd.vld\[8\] sky130_fd_sc_hd__dfrtp_1
XFILLER_1_165 VGND VGND VPWR VPWR sky130_fd_sc_hd__fill_2
XFILLER_1_110 VGND VGND VPWR VPWR sky130_fd_sc_hd__fill_2
XPHY_EDGE_ROW_3_Left_37 VGND VGND VPWR VPWR sky130_fd_sc_hd__decap_3
XFILLER_24_85 VPWR VGND VPWR VGND sky130_ef_sc_hd__decap_40_12
XFILLER_24_41 VPWR VGND VPWR VGND sky130_ef_sc_hd__decap_40_12
X_301_ net75 net80 net7 VGND VGND VPWR VPWR _027_ sky130_fd_sc_hd__mux2_1
X_232_ _060_ rng_rd.mem\[3\]\[2\] _120_ _121_ VGND VGND VPWR VPWR _122_ sky130_fd_sc_hd__o211a_1
XFILLER_28_139 VGND VGND VPWR VPWR sky130_fd_sc_hd__fill_1
Xhold19 _039_ VGND VGND VPWR VPWR net46 sky130_fd_sc_hd__dlygate4sd3_1
XFILLER_27_161 VGND VGND VPWR VPWR sky130_fd_sc_hd__fill_4
XFILLER_19_117 VGND VGND VPWR VPWR sky130_fd_sc_hd__fill_2
XFILLER_3_205 VPWR VGND VPWR VGND sky130_ef_sc_hd__decap_40_12
XFILLER_33_197 VPWR VGND VPWR VGND sky130_ef_sc_hd__decap_40_12
XFILLER_33_153 VPWR VGND VPWR VGND sky130_ef_sc_hd__decap_40_12
XFILLER_25_109 VGND VGND VPWR VPWR sky130_fd_sc_hd__fill_2
XFILLER_18_172 VGND VGND VPWR VPWR sky130_fd_sc_hd__fill_8
XFILLER_18_161 VGND VGND VPWR VPWR sky130_fd_sc_hd__fill_2
X_215_ net16 rng_rd.mem\[6\]\[2\] VGND VGND VPWR VPWR _105_ sky130_fd_sc_hd__xor2_1
XFILLER_24_197 VPWR VGND VPWR VGND sky130_ef_sc_hd__decap_40_12
XFILLER_24_153 VPWR VGND VPWR VGND sky130_ef_sc_hd__decap_40_12
XFILLER_30_189 VGND VGND VPWR VPWR sky130_fd_sc_hd__fill_4
XFILLER_15_197 VGND VGND VPWR VPWR sky130_fd_sc_hd__fill_2
XPHY_EDGE_ROW_6_Left_40 VGND VGND VPWR VPWR sky130_fd_sc_hd__decap_3
XFILLER_7_55 VGND VGND VPWR VPWR sky130_fd_sc_hd__fill_1
XFILLER_30_3 VPWR VGND VPWR VGND sky130_ef_sc_hd__decap_40_12
XFILLER_21_189 VPWR VGND VPWR VGND sky130_ef_sc_hd__decap_40_12
XFILLER_32_85 VPWR VGND VPWR VGND sky130_ef_sc_hd__decap_40_12
XFILLER_32_41 VPWR VGND VPWR VGND sky130_ef_sc_hd__decap_40_12
XPHY_EDGE_ROW_32_Left_66 VGND VGND VPWR VPWR sky130_fd_sc_hd__decap_3
XTAP_TAPCELL_ROW_22_151 VGND VPWR sky130_fd_sc_hd__tapvpwrvgnd_1
XFILLER_7_182 VGND VGND VPWR VPWR sky130_fd_sc_hd__fill_2
XFILLER_4_45 VGND VGND VPWR VPWR sky130_fd_sc_hd__fill_1
XFILLER_4_141 VGND VGND VPWR VPWR sky130_fd_sc_hd__fill_1
Xfanout22 net27 VGND VGND VPWR VPWR net22 sky130_fd_sc_hd__clkbuf_4
Xfanout11 net12 VGND VGND VPWR VPWR net11 sky130_fd_sc_hd__buf_2
X_377_ clknet_3_7__leaf_clk_i _043_ net26 VGND VGND VPWR VPWR rng_rd.vld\[7\] sky130_fd_sc_hd__dfrtp_1
XTAP_TAPCELL_ROW_0_68 VGND VPWR sky130_fd_sc_hd__tapvpwrvgnd_1
XFILLER_9_222 VGND VGND VPWR VPWR sky130_fd_sc_hd__fill_1
Xclkbuf_0_clk_i clk_i VGND VGND VPWR VPWR clknet_0_clk_i sky130_fd_sc_hd__clkbuf_16
XFILLER_24_97 VPWR VGND VPWR VGND sky130_ef_sc_hd__decap_40_12
XFILLER_24_53 VPWR VGND VPWR VGND sky130_ef_sc_hd__decap_40_12
X_231_ num_i_bar\[0\] _069_ _118_ _119_ rng_rd.vld\[3\] VGND VGND VPWR VPWR _121_
+ sky130_fd_sc_hd__o221a_1
X_300_ net64 rng_rd.mem\[2\]\[2\] net8 VGND VGND VPWR VPWR _026_ sky130_fd_sc_hd__mux2_1
XFILLER_10_221 VGND VGND VPWR VPWR sky130_fd_sc_hd__fill_2
Xinput1 req_num_i VGND VGND VPWR VPWR net1 sky130_fd_sc_hd__clkbuf_1
XFILLER_3_217 VGND VGND VPWR VPWR sky130_fd_sc_hd__fill_4
XFILLER_19_75 VGND VGND VPWR VPWR sky130_fd_sc_hd__fill_1
XFILLER_18_5 VGND VGND VPWR VPWR sky130_fd_sc_hd__fill_1
X_214_ _060_ rng_rd.mem\[11\]\[2\] _102_ _103_ VGND VGND VPWR VPWR _104_ sky130_fd_sc_hd__a211o_1
XFILLER_33_165 VGND VGND VPWR VPWR sky130_fd_sc_hd__fill_2
XFILLER_0_209 VPWR VGND VPWR VGND sky130_ef_sc_hd__decap_40_12
XTAP_TAPCELL_ROW_25_160 VGND VPWR sky130_fd_sc_hd__tapvpwrvgnd_1
XFILLER_24_165 VPWR VGND VPWR VGND sky130_ef_sc_hd__decap_40_12
XFILLER_23_3 VPWR VGND VPWR VGND sky130_ef_sc_hd__decap_40_12
XFILLER_21_113 VGND VGND VPWR VPWR sky130_fd_sc_hd__fill_2
XFILLER_32_97 VPWR VGND VPWR VGND sky130_ef_sc_hd__decap_40_12
XFILLER_32_53 VPWR VGND VPWR VGND sky130_ef_sc_hd__decap_40_12
XFILLER_8_139 VGND VGND VPWR VPWR sky130_fd_sc_hd__fill_1
XPHY_EDGE_ROW_9_Right_9 VGND VGND VPWR VPWR sky130_fd_sc_hd__decap_3
XFILLER_4_57 VGND VGND VPWR VPWR sky130_fd_sc_hd__fill_1
XFILLER_4_197 VPWR VGND VPWR VGND sky130_ef_sc_hd__decap_40_12
Xfanout12 _139_ VGND VGND VPWR VPWR net12 sky130_fd_sc_hd__clkbuf_2
Xfanout23 net27 VGND VGND VPWR VPWR net23 sky130_fd_sc_hd__buf_2
XFILLER_1_167 VGND VGND VPWR VPWR sky130_fd_sc_hd__fill_1
XTAP_TAPCELL_ROW_0_69 VGND VPWR sky130_fd_sc_hd__tapvpwrvgnd_1
X_376_ clknet_3_6__leaf_clk_i net42 net25 VGND VGND VPWR VPWR rng_rd.vld\[6\] sky130_fd_sc_hd__dfrtp_1
XFILLER_24_65 VPWR VGND VPWR VGND sky130_ef_sc_hd__decap_40_12
X_230_ _060_ rng_rd.mem\[3\]\[2\] rng_rd.mem\[3\]\[0\] net14 VGND VGND VPWR VPWR _120_
+ sky130_fd_sc_hd__o2bb2a_1
X_359_ clknet_3_3__leaf_clk_i net65 net23 VGND VGND VPWR VPWR rng_rd.mem\[3\]\[2\]
+ sky130_fd_sc_hd__dfrtp_1
XFILLER_1_25 VPWR VGND VPWR VGND sky130_ef_sc_hd__decap_40_12
Xinput2 rst_i VGND VGND VPWR VPWR net2 sky130_fd_sc_hd__clkbuf_1
XFILLER_19_54 VGND VGND VPWR VPWR sky130_fd_sc_hd__fill_2
X_213_ net14 rng_rd.mem\[11\]\[0\] _100_ _101_ _063_ VGND VGND VPWR VPWR _103_ sky130_fd_sc_hd__a221o_1
XFILLER_33_111 VGND VGND VPWR VPWR sky130_fd_sc_hd__fill_1
XFILLER_18_141 VGND VGND VPWR VPWR sky130_fd_sc_hd__fill_2
Xclkbuf_3_2__f_clk_i clknet_0_clk_i VGND VGND VPWR VPWR clknet_3_2__leaf_clk_i sky130_fd_sc_hd__clkbuf_16
XFILLER_24_177 VPWR VGND VPWR VGND sky130_ef_sc_hd__decap_40_12
XFILLER_21_33 VPWR VGND VPWR VGND sky130_ef_sc_hd__decap_40_12
XTAP_TAPCELL_ROW_25_161 VGND VPWR sky130_fd_sc_hd__tapvpwrvgnd_1
XFILLER_16_3 VGND VGND VPWR VPWR sky130_fd_sc_hd__fill_4
XFILLER_21_147 VGND VGND VPWR VPWR sky130_fd_sc_hd__fill_4
XFILLER_21_136 VGND VGND VPWR VPWR sky130_fd_sc_hd__fill_2
XFILLER_21_125 VGND VGND VPWR VPWR sky130_fd_sc_hd__fill_2
XFILLER_32_65 VPWR VGND VPWR VGND sky130_ef_sc_hd__decap_40_12
XFILLER_32_209 VPWR VGND VPWR VGND sky130_ef_sc_hd__decap_40_12
X_392_ clknet_3_1__leaf_clk_i _000_ net21 VGND VGND VPWR VPWR rng_rd.wr_pulse sky130_fd_sc_hd__dfrtp_1
XFILLER_14_209 VPWR VGND VPWR VGND sky130_ef_sc_hd__decap_40_12
XFILLER_13_23 VGND VGND VPWR VPWR sky130_fd_sc_hd__fill_2
Xfanout13 _059_ VGND VGND VPWR VPWR net13 sky130_fd_sc_hd__buf_2
XFILLER_1_113 VPWR VGND VPWR VGND sky130_ef_sc_hd__decap_40_12
Xfanout24 net26 VGND VGND VPWR VPWR net24 sky130_fd_sc_hd__clkbuf_4
X_375_ clknet_3_3__leaf_clk_i _041_ net25 VGND VGND VPWR VPWR rng_rd.vld\[5\] sky130_fd_sc_hd__dfrtp_1
XFILLER_24_77 VGND VGND VPWR VPWR sky130_fd_sc_hd__fill_4
X_358_ clknet_3_3__leaf_clk_i _025_ net23 VGND VGND VPWR VPWR rng_rd.mem\[3\]\[1\]
+ sky130_fd_sc_hd__dfrtp_1
XFILLER_1_37 VGND VGND VPWR VPWR sky130_fd_sc_hd__fill_2
XFILLER_6_205 VPWR VGND VPWR VGND sky130_ef_sc_hd__decap_40_12
XFILLER_28_109 VPWR VGND VPWR VGND sky130_ef_sc_hd__decap_40_12
XPHY_EDGE_ROW_27_Right_27 VGND VGND VPWR VPWR sky130_fd_sc_hd__decap_3
XPHY_EDGE_ROW_18_Right_18 VGND VGND VPWR VPWR sky130_fd_sc_hd__decap_3
X_289_ net82 rng_rd.mem\[5\]\[0\] net10 VGND VGND VPWR VPWR _015_ sky130_fd_sc_hd__mux2_1
Xinput3 wr_i VGND VGND VPWR VPWR net3 sky130_fd_sc_hd__clkbuf_1
X_212_ net14 rng_rd.mem\[11\]\[0\] rng_rd.mem\[11\]\[2\] _060_ VGND VGND VPWR VPWR
+ _102_ sky130_fd_sc_hd__o22ai_1
XFILLER_10_24 VGND VGND VPWR VPWR sky130_fd_sc_hd__fill_4
XFILLER_33_167 VGND VGND VPWR VPWR sky130_fd_sc_hd__fill_1
XTAP_TAPCELL_ROW_28_170 VGND VPWR sky130_fd_sc_hd__tapvpwrvgnd_1
XFILLER_18_197 VGND VGND VPWR VPWR sky130_fd_sc_hd__fill_1
XFILLER_24_189 VGND VGND VPWR VPWR sky130_fd_sc_hd__fill_4
XFILLER_21_45 VGND VGND VPWR VPWR sky130_fd_sc_hd__fill_2
XFILLER_21_23 VGND VGND VPWR VPWR sky130_fd_sc_hd__fill_2
XFILLER_30_137 VGND VGND VPWR VPWR sky130_fd_sc_hd__fill_2
XFILLER_15_167 VGND VGND VPWR VPWR sky130_fd_sc_hd__fill_1
XFILLER_21_115 VGND VGND VPWR VPWR sky130_fd_sc_hd__fill_1
XFILLER_32_77 VGND VGND VPWR VPWR sky130_fd_sc_hd__fill_4
XPHY_EDGE_ROW_0_Right_0 VGND VGND VPWR VPWR sky130_fd_sc_hd__decap_3
XFILLER_27_55 VGND VGND VPWR VPWR sky130_fd_sc_hd__fill_1
X_391_ clknet_3_5__leaf_clk_i _056_ net26 VGND VGND VPWR VPWR rng_rd.mem\[9\]\[2\]
+ sky130_fd_sc_hd__dfrtp_1
XFILLER_31_221 VGND VGND VPWR VPWR sky130_fd_sc_hd__fill_2
XFILLER_4_15 VGND VGND VPWR VPWR sky130_fd_sc_hd__fill_2
XFILLER_22_221 VGND VGND VPWR VPWR sky130_fd_sc_hd__fill_2
Xfanout25 net26 VGND VGND VPWR VPWR net25 sky130_fd_sc_hd__clkbuf_4
XFILLER_1_125 VPWR VGND VPWR VGND sky130_ef_sc_hd__decap_40_12
Xfanout14 _057_ VGND VGND VPWR VPWR net14 sky130_fd_sc_hd__buf_2
X_374_ clknet_3_3__leaf_clk_i _040_ net23 VGND VGND VPWR VPWR rng_rd.vld\[4\] sky130_fd_sc_hd__dfrtp_1
XFILLER_13_221 VGND VGND VPWR VPWR sky130_fd_sc_hd__fill_2
XFILLER_1_169 VPWR VGND VPWR VGND sky130_ef_sc_hd__decap_40_12
XFILLER_5_91 VGND VGND VPWR VPWR sky130_fd_sc_hd__fill_4
XFILLER_6_3 VGND VGND VPWR VPWR sky130_fd_sc_hd__fill_4
XFILLER_6_217 VGND VGND VPWR VPWR sky130_fd_sc_hd__fill_4
XPHY_EDGE_ROW_23_Left_57 VGND VGND VPWR VPWR sky130_fd_sc_hd__decap_3
X_357_ clknet_3_3__leaf_clk_i net76 net23 VGND VGND VPWR VPWR rng_rd.mem\[3\]\[0\]
+ sky130_fd_sc_hd__dfrtp_1
X_288_ net81 net63 net9 VGND VGND VPWR VPWR _014_ sky130_fd_sc_hd__mux2_1
XFILLER_27_165 VGND VGND VPWR VPWR sky130_fd_sc_hd__fill_2
X_211_ net19 rng_rd.mem\[11\]\[1\] VGND VGND VPWR VPWR _101_ sky130_fd_sc_hd__nand2_1
XFILLER_33_113 VPWR VGND VPWR VGND sky130_ef_sc_hd__decap_40_12
XTAP_TAPCELL_ROW_28_171 VGND VPWR sky130_fd_sc_hd__tapvpwrvgnd_1
XFILLER_21_57 VGND VGND VPWR VPWR sky130_fd_sc_hd__fill_2
XFILLER_7_15 VPWR VGND VPWR VGND sky130_ef_sc_hd__decap_40_12
XFILLER_29_205 VPWR VGND VPWR VGND sky130_ef_sc_hd__decap_40_12
XPHY_EDGE_ROW_26_Left_60 VGND VGND VPWR VPWR sky130_fd_sc_hd__decap_3
XFILLER_21_127 VGND VGND VPWR VPWR sky130_fd_sc_hd__fill_1
XTAP_TAPCELL_ROW_16_130 VGND VPWR sky130_fd_sc_hd__tapvpwrvgnd_1
XPHY_EDGE_ROW_10_Left_44 VGND VGND VPWR VPWR sky130_fd_sc_hd__decap_3
XFILLER_12_138 VGND VGND VPWR VPWR sky130_fd_sc_hd__fill_2
XFILLER_21_3 VPWR VGND VPWR VGND sky130_ef_sc_hd__decap_40_12
X_390_ clknet_3_5__leaf_clk_i net87 net26 VGND VGND VPWR VPWR rng_rd.mem\[9\]\[1\]
+ sky130_fd_sc_hd__dfrtp_1
XFILLER_4_49 VGND VGND VPWR VPWR sky130_fd_sc_hd__fill_4
Xfanout15 _057_ VGND VGND VPWR VPWR net15 sky130_fd_sc_hd__clkbuf_2
Xfanout26 net27 VGND VGND VPWR VPWR net26 sky130_fd_sc_hd__buf_2
X_373_ clknet_3_2__leaf_clk_i net46 net23 VGND VGND VPWR VPWR rng_rd.vld\[3\] sky130_fd_sc_hd__dfrtp_1
XFILLER_1_137 VPWR VGND VPWR VGND sky130_ef_sc_hd__decap_40_12
XFILLER_0_181 VPWR VGND VPWR VGND sky130_ef_sc_hd__decap_40_12
X_287_ net88 net86 net9 VGND VGND VPWR VPWR _013_ sky130_fd_sc_hd__mux2_1
X_356_ clknet_3_0__leaf_clk_i net3 net20 VGND VGND VPWR VPWR rng_rd.wr_ff1 sky130_fd_sc_hd__dfrtp_1
XFILLER_27_111 VGND VGND VPWR VPWR sky130_fd_sc_hd__fill_1
XFILLER_19_57 VGND VGND VPWR VPWR sky130_fd_sc_hd__fill_4
XFILLER_33_169 VPWR VGND VPWR VGND sky130_ef_sc_hd__decap_40_12
XFILLER_33_125 VPWR VGND VPWR VGND sky130_ef_sc_hd__decap_40_12
XTAP_TAPCELL_ROW_28_172 VGND VPWR sky130_fd_sc_hd__tapvpwrvgnd_1
XFILLER_2_221 VGND VGND VPWR VPWR sky130_fd_sc_hd__fill_2
X_210_ net19 rng_rd.mem\[11\]\[1\] VGND VGND VPWR VPWR _100_ sky130_fd_sc_hd__or2_1
XFILLER_24_125 VPWR VGND VPWR VGND sky130_ef_sc_hd__decap_40_12
X_339_ clknet_3_0__leaf_clk_i _001_ net20 VGND VGND VPWR VPWR rng_dp.seed_sel_i\[0\]
+ sky130_fd_sc_hd__dfrtp_2
XFILLER_30_139 VGND VGND VPWR VPWR sky130_fd_sc_hd__fill_1
XFILLER_21_47 VGND VGND VPWR VPWR sky130_fd_sc_hd__fill_1
XFILLER_11_91 VGND VGND VPWR VPWR sky130_fd_sc_hd__fill_2
XFILLER_29_217 VGND VGND VPWR VPWR sky130_fd_sc_hd__fill_4
XFILLER_16_47 VGND VGND VPWR VPWR sky130_fd_sc_hd__fill_1
XFILLER_11_183 VGND VGND VPWR VPWR sky130_fd_sc_hd__fill_1
XFILLER_26_209 VPWR VGND VPWR VGND sky130_ef_sc_hd__decap_40_12
XFILLER_27_57 VPWR VGND VPWR VGND sky130_ef_sc_hd__decap_40_12
XFILLER_17_209 VPWR VGND VPWR VGND sky130_ef_sc_hd__decap_40_12
XFILLER_8_81 VGND VGND VPWR VPWR sky130_fd_sc_hd__fill_2
Xfanout16 net17 VGND VGND VPWR VPWR net16 sky130_fd_sc_hd__clkbuf_4
Xfanout27 net2 VGND VGND VPWR VPWR net27 sky130_fd_sc_hd__dlymetal6s2s_1
X_372_ clknet_3_2__leaf_clk_i _038_ net22 VGND VGND VPWR VPWR rng_rd.vld\[2\] sky130_fd_sc_hd__dfrtp_1
XFILLER_13_48 VGND VGND VPWR VPWR sky130_fd_sc_hd__fill_8
XFILLER_1_149 VPWR VGND VPWR VGND sky130_ef_sc_hd__decap_40_12
XFILLER_0_193 VGND VGND VPWR VPWR sky130_fd_sc_hd__fill_2
Xclkbuf_3_5__f_clk_i clknet_0_clk_i VGND VGND VPWR VPWR clknet_3_5__leaf_clk_i sky130_fd_sc_hd__clkbuf_16
X_355_ clknet_3_3__leaf_clk_i _023_ net23 VGND VGND VPWR VPWR rng_rd.mem\[4\]\[2\]
+ sky130_fd_sc_hd__dfrtp_1
X_286_ rng_rd.mem\[10\]\[0\] net84 net9 VGND VGND VPWR VPWR _012_ sky130_fd_sc_hd__mux2_1
XFILLER_27_167 VGND VGND VPWR VPWR sky130_fd_sc_hd__fill_1
XPHY_EDGE_ROW_23_Right_23 VGND VGND VPWR VPWR sky130_fd_sc_hd__decap_3
XPHY_EDGE_ROW_14_Right_14 VGND VGND VPWR VPWR sky130_fd_sc_hd__decap_3
XFILLER_33_137 VGND VGND VPWR VPWR sky130_fd_sc_hd__fill_2
XPHY_EDGE_ROW_32_Right_32 VGND VGND VPWR VPWR sky130_fd_sc_hd__decap_3
XFILLER_24_137 VGND VGND VPWR VPWR sky130_fd_sc_hd__fill_2
XTAP_TAPCELL_ROW_19_140 VGND VPWR sky130_fd_sc_hd__tapvpwrvgnd_1
X_269_ _138_ _140_ VGND VGND VPWR VPWR _152_ sky130_fd_sc_hd__or2_1
X_338_ clknet_3_0__leaf_clk_i _008_ net20 VGND VGND VPWR VPWR num_i_bar\[2\] sky130_fd_sc_hd__dfrtp_1
XFILLER_21_59 VGND VGND VPWR VPWR sky130_fd_sc_hd__fill_1
XFILLER_21_15 VGND VGND VPWR VPWR sky130_fd_sc_hd__fill_8
XFILLER_16_7 VGND VGND VPWR VPWR sky130_fd_sc_hd__fill_1
XFILLER_11_70 VGND VGND VPWR VPWR sky130_fd_sc_hd__fill_1
XFILLER_20_195 VGND VGND VPWR VPWR sky130_fd_sc_hd__fill_1
XFILLER_16_37 VGND VGND VPWR VPWR sky130_fd_sc_hd__fill_1
XFILLER_12_118 VPWR VGND VPWR VGND sky130_ef_sc_hd__decap_40_12
XFILLER_7_155 VGND VGND VPWR VPWR sky130_fd_sc_hd__fill_1
XPHY_EDGE_ROW_4_Right_4 VGND VGND VPWR VPWR sky130_fd_sc_hd__decap_3
XFILLER_8_71 VGND VGND VPWR VPWR sky130_fd_sc_hd__fill_2
XFILLER_27_69 VPWR VGND VPWR VGND sky130_ef_sc_hd__decap_40_12
XFILLER_25_221 VGND VGND VPWR VPWR sky130_fd_sc_hd__fill_2
XFILLER_16_221 VGND VGND VPWR VPWR sky130_fd_sc_hd__fill_2
X_371_ clknet_3_2__leaf_clk_i _037_ net22 VGND VGND VPWR VPWR rng_rd.vld\[1\] sky130_fd_sc_hd__dfrtp_1
Xfanout17 num_i_bar\[2\] VGND VGND VPWR VPWR net17 sky130_fd_sc_hd__buf_2
XFILLER_24_15 VPWR VGND VPWR VGND sky130_ef_sc_hd__decap_40_12
X_354_ clknet_3_3__leaf_clk_i net58 net22 VGND VGND VPWR VPWR rng_rd.mem\[4\]\[1\]
+ sky130_fd_sc_hd__dfrtp_1
X_285_ rng_rd.mem\[7\]\[2\] net54 net11 VGND VGND VPWR VPWR _011_ sky130_fd_sc_hd__mux2_1
XFILLER_5_220 VGND VGND VPWR VPWR sky130_fd_sc_hd__fill_2
XFILLER_27_113 VPWR VGND VPWR VGND sky130_ef_sc_hd__decap_40_12
XFILLER_19_37 VGND VGND VPWR VPWR sky130_fd_sc_hd__fill_4
XFILLER_4_3 VPWR VGND VPWR VGND sky130_ef_sc_hd__decap_40_12
X_199_ net14 rng_rd.mem\[2\]\[0\] _085_ _088_ VGND VGND VPWR VPWR _089_ sky130_fd_sc_hd__o211a_1
XFILLER_2_62 VGND VGND VPWR VPWR sky130_fd_sc_hd__fill_8
X_268_ _144_ _147_ _151_ _136_ num_i_bar\[0\] VGND VGND VPWR VPWR _006_ sky130_fd_sc_hd__o32a_1
X_337_ clknet_3_1__leaf_clk_i _007_ net21 VGND VGND VPWR VPWR num_i_bar\[1\] sky130_fd_sc_hd__dfrtp_1
XFILLER_32_193 VGND VGND VPWR VPWR sky130_fd_sc_hd__fill_2
XFILLER_21_108 VGND VGND VPWR VPWR sky130_fd_sc_hd__fill_4
XFILLER_32_15 VPWR VGND VPWR VGND sky130_ef_sc_hd__decap_40_12
XFILLER_20_141 VGND VGND VPWR VPWR sky130_fd_sc_hd__fill_4
XFILLER_14_193 VGND VGND VPWR VPWR sky130_fd_sc_hd__fill_2
XPHY_EDGE_ROW_14_Left_48 VGND VGND VPWR VPWR sky130_fd_sc_hd__decap_3
XFILLER_7_178 VGND VGND VPWR VPWR sky130_fd_sc_hd__fill_4
XFILLER_8_83 VGND VGND VPWR VPWR sky130_fd_sc_hd__fill_1
XFILLER_27_15 VPWR VGND VPWR VGND sky130_ef_sc_hd__decap_40_12
XFILLER_4_137 VGND VGND VPWR VPWR sky130_fd_sc_hd__fill_2
XFILLER_4_159 VPWR VGND VPWR VGND sky130_ef_sc_hd__decap_40_12
XTAP_TAPCELL_ROW_10_106 VGND VPWR sky130_fd_sc_hd__tapvpwrvgnd_1
XFILLER_3_181 VPWR VGND VPWR VGND sky130_ef_sc_hd__decap_40_12
Xfanout18 num_i_bar\[1\] VGND VGND VPWR VPWR net18 sky130_fd_sc_hd__buf_2
X_370_ clknet_3_2__leaf_clk_i _036_ net22 VGND VGND VPWR VPWR rng_rd.vld\[0\] sky130_fd_sc_hd__dfrtp_1
XFILLER_0_195 VGND VGND VPWR VPWR sky130_fd_sc_hd__fill_1
XFILLER_24_27 VGND VGND VPWR VPWR sky130_fd_sc_hd__fill_1
X_284_ rng_rd.mem\[7\]\[1\] net71 net11 VGND VGND VPWR VPWR _010_ sky130_fd_sc_hd__mux2_1
X_353_ clknet_3_3__leaf_clk_i net93 net22 VGND VGND VPWR VPWR rng_rd.mem\[4\]\[0\]
+ sky130_fd_sc_hd__dfrtp_1
XPHY_EDGE_ROW_17_Left_51 VGND VGND VPWR VPWR sky130_fd_sc_hd__decap_3
XFILLER_6_7 VGND VGND VPWR VPWR sky130_fd_sc_hd__fill_1
XFILLER_30_81 VGND VGND VPWR VPWR sky130_fd_sc_hd__fill_2
XFILLER_27_169 VPWR VGND VPWR VGND sky130_ef_sc_hd__decap_40_12
XFILLER_27_125 VPWR VGND VPWR VGND sky130_ef_sc_hd__decap_40_12
XPHY_EDGE_ROW_2_Left_36 VGND VGND VPWR VPWR sky130_fd_sc_hd__decap_3
XFILLER_10_29 VGND VGND VPWR VPWR sky130_fd_sc_hd__fill_1
XFILLER_33_139 VGND VGND VPWR VPWR sky130_fd_sc_hd__fill_1
XFILLER_25_81 VPWR VGND VPWR VGND sky130_ef_sc_hd__decap_40_12
X_198_ net13 rng_rd.mem\[2\]\[1\] _086_ _087_ rng_rd.vld\[2\] VGND VGND VPWR VPWR
+ _088_ sky130_fd_sc_hd__o221a_1
X_267_ _136_ _150_ VGND VGND VPWR VPWR _151_ sky130_fd_sc_hd__nand2_1
X_336_ clknet_3_1__leaf_clk_i _006_ net20 VGND VGND VPWR VPWR num_i_bar\[0\] sky130_fd_sc_hd__dfrtp_4
XFILLER_24_139 VGND VGND VPWR VPWR sky130_fd_sc_hd__fill_1
XFILLER_2_52 VGND VGND VPWR VPWR sky130_fd_sc_hd__fill_2
XFILLER_30_109 VPWR VGND VPWR VGND sky130_ef_sc_hd__decap_40_12
XFILLER_23_161 VGND VGND VPWR VPWR sky130_fd_sc_hd__fill_4
XFILLER_15_128 VGND VGND VPWR VPWR sky130_fd_sc_hd__fill_2
X_319_ net44 net36 net11 VGND VGND VPWR VPWR _045_ sky130_fd_sc_hd__mux2_1
XFILLER_32_27 VGND VGND VPWR VPWR sky130_fd_sc_hd__fill_1
XTAP_TAPCELL_ROW_22_148 VGND VPWR sky130_fd_sc_hd__tapvpwrvgnd_1
XFILLER_20_197 VPWR VGND VPWR VGND sky130_ef_sc_hd__decap_40_12
XFILLER_20_120 VGND VGND VPWR VPWR sky130_fd_sc_hd__fill_1
XFILLER_22_82 VGND VGND VPWR VPWR sky130_fd_sc_hd__fill_2
XFILLER_7_102 VGND VGND VPWR VPWR sky130_fd_sc_hd__fill_2
XFILLER_27_27 VPWR VGND VPWR VGND sky130_ef_sc_hd__decap_40_12
XTAP_TAPCELL_ROW_10_107 VGND VPWR sky130_fd_sc_hd__tapvpwrvgnd_1
XFILLER_8_62 VGND VGND VPWR VPWR sky130_fd_sc_hd__fill_2
XFILLER_33_81 VGND VGND VPWR VPWR sky130_fd_sc_hd__fill_2
XPHY_EDGE_ROW_31_Left_65 VGND VGND VPWR VPWR sky130_fd_sc_hd__decap_3
XTAP_TAPCELL_ROW_4_85 VGND VPWR sky130_fd_sc_hd__tapvpwrvgnd_1
XFILLER_3_193 VPWR VGND VPWR VGND sky130_ef_sc_hd__decap_40_12
Xfanout19 num_i_bar\[1\] VGND VGND VPWR VPWR net19 sky130_fd_sc_hd__dlymetal6s2s_1
XFILLER_0_141 VPWR VGND VPWR VGND sky130_ef_sc_hd__decap_40_12
XFILLER_9_208 VPWR VGND VPWR VGND sky130_ef_sc_hd__decap_40_12
XFILLER_28_81 VGND VGND VPWR VPWR sky130_fd_sc_hd__fill_2
X_283_ net66 rng_rd.mem\[6\]\[0\] net11 VGND VGND VPWR VPWR _009_ sky130_fd_sc_hd__mux2_1
X_352_ clknet_3_6__leaf_clk_i _020_ net25 VGND VGND VPWR VPWR rng_rd.mem\[5\]\[2\]
+ sky130_fd_sc_hd__dfrtp_1
XTAP_TAPCELL_ROW_1_75 VGND VPWR sky130_fd_sc_hd__tapvpwrvgnd_1
XFILLER_5_222 VGND VGND VPWR VPWR sky130_fd_sc_hd__fill_1
XFILLER_27_137 VPWR VGND VPWR VGND sky130_ef_sc_hd__decap_40_12
XFILLER_25_93 VPWR VGND VPWR VGND sky130_ef_sc_hd__decap_40_12
XFILLER_18_115 VGND VGND VPWR VPWR sky130_fd_sc_hd__fill_4
X_197_ net17 rng_rd.mem\[2\]\[2\] VGND VGND VPWR VPWR _087_ sky130_fd_sc_hd__nor2_1
X_266_ rng_dp.inst.next_num_o\[0\] _066_ _148_ _149_ VGND VGND VPWR VPWR _150_ sky130_fd_sc_hd__a22o_1
X_335_ clknet_3_1__leaf_clk_i net53 net20 VGND VGND VPWR VPWR rng_rd.mem\[11\]\[2\]
+ sky130_fd_sc_hd__dfrtp_1
XFILLER_32_195 VGND VGND VPWR VPWR sky130_fd_sc_hd__fill_1
XPHY_EDGE_ROW_10_Right_10 VGND VGND VPWR VPWR sky130_fd_sc_hd__decap_3
XTAP_TAPCELL_ROW_33_190 VGND VPWR sky130_fd_sc_hd__tapvpwrvgnd_1
XFILLER_14_195 VGND VGND VPWR VPWR sky130_fd_sc_hd__fill_1
X_318_ net36 rng_rd.vld\[7\] net9 VGND VGND VPWR VPWR _044_ sky130_fd_sc_hd__mux2_1
X_249_ rng_dp.seed_sel_i\[1\] _001_ VGND VGND VPWR VPWR _137_ sky130_fd_sc_hd__or2_1
XTAP_TAPCELL_ROW_7_96 VGND VPWR sky130_fd_sc_hd__tapvpwrvgnd_1
XFILLER_28_221 VGND VGND VPWR VPWR sky130_fd_sc_hd__fill_2
XTAP_TAPCELL_ROW_22_149 VGND VPWR sky130_fd_sc_hd__tapvpwrvgnd_1
XFILLER_20_187 VGND VGND VPWR VPWR sky130_fd_sc_hd__fill_8
XFILLER_22_94 VGND VGND VPWR VPWR sky130_fd_sc_hd__fill_2
XFILLER_19_221 VGND VGND VPWR VPWR sky130_fd_sc_hd__fill_2
XFILLER_27_39 VPWR VGND VPWR VGND sky130_ef_sc_hd__decap_40_12
XFILLER_31_205 VPWR VGND VPWR VGND sky130_ef_sc_hd__decap_40_12
XTAP_TAPCELL_ROW_10_108 VGND VPWR sky130_fd_sc_hd__tapvpwrvgnd_1
XFILLER_4_139 VGND VGND VPWR VPWR sky130_fd_sc_hd__fill_1
XFILLER_13_19 VGND VGND VPWR VPWR sky130_fd_sc_hd__fill_4
XFILLER_3_161 VGND VGND VPWR VPWR sky130_fd_sc_hd__fill_4
XTAP_TAPCELL_ROW_4_86 VGND VPWR sky130_fd_sc_hd__tapvpwrvgnd_1
Xhold1 rng_rd.wr_ff1 VGND VGND VPWR VPWR net28 sky130_fd_sc_hd__dlygate4sd3_1
XPHY_EDGE_ROW_8_Right_8 VGND VGND VPWR VPWR sky130_fd_sc_hd__decap_3
XFILLER_13_205 VPWR VGND VPWR VGND sky130_ef_sc_hd__decap_40_12
XFILLER_0_197 VPWR VGND VPWR VGND sky130_ef_sc_hd__decap_40_12
XFILLER_0_153 VPWR VGND VPWR VGND sky130_ef_sc_hd__decap_40_12
XFILLER_8_220 VGND VGND VPWR VPWR sky130_fd_sc_hd__fill_2
XFILLER_24_29 VPWR VGND VPWR VGND sky130_ef_sc_hd__decap_40_12
XFILLER_30_83 VGND VGND VPWR VPWR sky130_fd_sc_hd__fill_1
X_351_ clknet_3_6__leaf_clk_i net74 net25 VGND VGND VPWR VPWR rng_rd.mem\[5\]\[1\]
+ sky130_fd_sc_hd__dfrtp_1
XTAP_TAPCELL_ROW_1_76 VGND VPWR sky130_fd_sc_hd__tapvpwrvgnd_1
X_282_ _163_ _161_ _136_ net17 VGND VGND VPWR VPWR _008_ sky130_fd_sc_hd__o2bb2a_1
XFILLER_27_149 VPWR VGND VPWR VGND sky130_ef_sc_hd__decap_40_12
XFILLER_27_105 VGND VGND VPWR VPWR sky130_fd_sc_hd__fill_4
XFILLER_26_193 VGND VGND VPWR VPWR sky130_fd_sc_hd__fill_2
X_334_ clknet_3_1__leaf_clk_i _004_ net20 VGND VGND VPWR VPWR rng_rd.mem\[11\]\[1\]
+ sky130_fd_sc_hd__dfrtp_1
XFILLER_32_141 VPWR VGND VPWR VGND sky130_ef_sc_hd__decap_40_12
X_196_ net17 rng_rd.mem\[2\]\[2\] VGND VGND VPWR VPWR _086_ sky130_fd_sc_hd__and2_1
XFILLER_2_54 VGND VGND VPWR VPWR sky130_fd_sc_hd__fill_1
X_265_ rng_dp.inst.next_num_o\[2\] rng_dp.inst.next_num_o\[1\] _137_ VGND VGND VPWR
+ VPWR _149_ sky130_fd_sc_hd__a21o_1
XTAP_TAPCELL_ROW_33_191 VGND VPWR sky130_fd_sc_hd__tapvpwrvgnd_1
XFILLER_23_130 VPWR VGND VPWR VGND sky130_ef_sc_hd__decap_40_12
XFILLER_15_119 VGND VGND VPWR VPWR sky130_fd_sc_hd__fill_1
X_317_ net43 net41 net11 VGND VGND VPWR VPWR _043_ sky130_fd_sc_hd__mux2_1
X_179_ rng_rd.mem\[3\]\[0\] VGND VGND VPWR VPWR _069_ sky130_fd_sc_hd__inv_2
XFILLER_14_141 VGND VGND VPWR VPWR sky130_fd_sc_hd__fill_4
XTAP_TAPCELL_ROW_7_97 VGND VPWR sky130_fd_sc_hd__tapvpwrvgnd_1
X_248_ net30 net29 VGND VGND VPWR VPWR _000_ sky130_fd_sc_hd__and2b_1
XFILLER_32_29 VPWR VGND VPWR VGND sky130_ef_sc_hd__decap_40_12
XTAP_TAPCELL_ROW_13_117 VGND VPWR sky130_fd_sc_hd__tapvpwrvgnd_1
XFILLER_11_111 VGND VGND VPWR VPWR sky130_fd_sc_hd__fill_1
XFILLER_8_53 VGND VGND VPWR VPWR sky130_fd_sc_hd__fill_1
XFILLER_8_64 VGND VGND VPWR VPWR sky130_fd_sc_hd__fill_1
XFILLER_31_217 VGND VGND VPWR VPWR sky130_fd_sc_hd__fill_4
XFILLER_17_95 VGND VGND VPWR VPWR sky130_fd_sc_hd__fill_1
XTAP_TAPCELL_ROW_10_109 VGND VPWR sky130_fd_sc_hd__tapvpwrvgnd_1
XFILLER_4_129 VGND VGND VPWR VPWR sky130_fd_sc_hd__fill_8
XFILLER_33_83 VGND VGND VPWR VPWR sky130_fd_sc_hd__fill_1
XTAP_TAPCELL_ROW_4_87 VGND VPWR sky130_fd_sc_hd__tapvpwrvgnd_1
Xhold2 rng_rd.wr_ff2 VGND VGND VPWR VPWR net29 sky130_fd_sc_hd__dlygate4sd3_1
XFILLER_13_217 VGND VGND VPWR VPWR sky130_fd_sc_hd__fill_4
XFILLER_28_83 VGND VGND VPWR VPWR sky130_fd_sc_hd__fill_1
XFILLER_0_165 VGND VGND VPWR VPWR sky130_fd_sc_hd__fill_2
XFILLER_10_209 VPWR VGND VPWR VGND sky130_ef_sc_hd__decap_40_12
XFILLER_5_65 VGND VGND VPWR VPWR sky130_fd_sc_hd__fill_2
X_350_ clknet_3_6__leaf_clk_i _018_ net25 VGND VGND VPWR VPWR rng_rd.mem\[5\]\[0\]
+ sky130_fd_sc_hd__dfrtp_1
XFILLER_14_85 VGND VGND VPWR VPWR sky130_fd_sc_hd__fill_4
XTAP_TAPCELL_ROW_1_77 VGND VPWR sky130_fd_sc_hd__tapvpwrvgnd_1
X_281_ _142_ _156_ _162_ _136_ VGND VGND VPWR VPWR _163_ sky130_fd_sc_hd__o31a_1
XFILLER_33_109 VGND VGND VPWR VPWR sky130_fd_sc_hd__fill_2
XFILLER_25_51 VGND VGND VPWR VPWR sky130_fd_sc_hd__fill_4
XFILLER_24_109 VGND VGND VPWR VPWR sky130_fd_sc_hd__fill_8
X_195_ net14 rng_rd.mem\[2\]\[0\] rng_rd.mem\[2\]\[1\] net13 VGND VGND VPWR VPWR _085_
+ sky130_fd_sc_hd__a22oi_1
X_264_ _064_ rng_dp.inst.next_num_o\[2\] rng_dp.seed_sel_i\[1\] rng_dp.seed_sel_i\[0\]
+ VGND VGND VPWR VPWR _148_ sky130_fd_sc_hd__a211o_1
X_333_ clknet_3_4__leaf_clk_i net48 net24 VGND VGND VPWR VPWR rng_rd.mem\[11\]\[0\]
+ sky130_fd_sc_hd__dfrtp_1
XFILLER_32_197 VPWR VGND VPWR VGND sky130_ef_sc_hd__decap_40_12
XFILLER_32_153 VPWR VGND VPWR VGND sky130_ef_sc_hd__decap_40_12
XTAP_TAPCELL_ROW_25_159 VGND VPWR sky130_fd_sc_hd__tapvpwrvgnd_1
XFILLER_23_142 VGND VGND VPWR VPWR sky130_fd_sc_hd__fill_2
XTAP_TAPCELL_ROW_33_192 VGND VPWR sky130_fd_sc_hd__tapvpwrvgnd_1
X_316_ net41 rng_rd.vld\[5\] net10 VGND VGND VPWR VPWR _042_ sky130_fd_sc_hd__mux2_1
XFILLER_14_197 VPWR VGND VPWR VGND sky130_ef_sc_hd__decap_40_12
X_247_ _135_ _136_ VGND VGND VPWR VPWR req_num_again sky130_fd_sc_hd__and2b_1
XTAP_TAPCELL_ROW_7_98 VGND VPWR sky130_fd_sc_hd__tapvpwrvgnd_1
XFILLER_28_3 VPWR VGND VPWR VGND sky130_ef_sc_hd__decap_40_12
XFILLER_20_167 VGND VGND VPWR VPWR sky130_fd_sc_hd__fill_2
XFILLER_20_145 VGND VGND VPWR VPWR sky130_fd_sc_hd__fill_2
X_178_ rng_rd.mem\[1\]\[1\] VGND VGND VPWR VPWR _068_ sky130_fd_sc_hd__inv_2
XFILLER_22_74 VGND VGND VPWR VPWR sky130_fd_sc_hd__fill_8
XFILLER_22_41 VGND VGND VPWR VPWR sky130_fd_sc_hd__fill_4
XTAP_TAPCELL_ROW_13_118 VGND VPWR sky130_fd_sc_hd__tapvpwrvgnd_1
XFILLER_11_123 VGND VGND VPWR VPWR sky130_fd_sc_hd__fill_1
XFILLER_6_193 VGND VGND VPWR VPWR sky130_fd_sc_hd__fill_2
XFILLER_17_74 VGND VGND VPWR VPWR sky130_fd_sc_hd__fill_1
XTAP_TAPCELL_ROW_4_88 VGND VPWR sky130_fd_sc_hd__tapvpwrvgnd_1
Xhold3 rng_rd.wr_ff2_d VGND VGND VPWR VPWR net30 sky130_fd_sc_hd__dlygate4sd3_1
XPHY_EDGE_ROW_9_Left_43 VGND VGND VPWR VPWR sky130_fd_sc_hd__decap_3
XFILLER_0_111 VGND VGND VPWR VPWR sky130_fd_sc_hd__fill_1
XFILLER_5_55 VGND VGND VPWR VPWR sky130_fd_sc_hd__fill_1
XFILLER_8_222 VGND VGND VPWR VPWR sky130_fd_sc_hd__fill_1
XFILLER_10_3 VGND VGND VPWR VPWR sky130_fd_sc_hd__fill_1
XFILLER_30_41 VPWR VGND VPWR VGND sky130_ef_sc_hd__decap_40_12
X_280_ rng_dp.inst.next_num_o\[1\] _145_ VGND VGND VPWR VPWR _162_ sky130_fd_sc_hd__nor2_1
XFILLER_30_85 VPWR VGND VPWR VGND sky130_ef_sc_hd__decap_40_12
XFILLER_29_181 VPWR VGND VPWR VGND sky130_ef_sc_hd__decap_40_12
XFILLER_26_195 VGND VGND VPWR VPWR sky130_fd_sc_hd__fill_1
XPHY_EDGE_ROW_22_Left_56 VGND VGND VPWR VPWR sky130_fd_sc_hd__decap_3
X_194_ _079_ _082_ _083_ VGND VGND VPWR VPWR _084_ sky130_fd_sc_hd__and3_1
X_263_ _142_ _145_ rng_dp.seed_sel_i\[1\] rng_dp.seed_sel_i\[0\] VGND VGND VPWR VPWR
+ _147_ sky130_fd_sc_hd__o211a_1
X_332_ net63 net60 net9 VGND VGND VPWR VPWR _056_ sky130_fd_sc_hd__mux2_1
XFILLER_32_165 VPWR VGND VPWR VGND sky130_ef_sc_hd__decap_40_12
XFILLER_32_121 VPWR VGND VPWR VGND sky130_ef_sc_hd__decap_40_12
XFILLER_17_173 VGND VGND VPWR VPWR sky130_fd_sc_hd__fill_2
XTAP_TAPCELL_ROW_33_193 VGND VPWR sky130_fd_sc_hd__tapvpwrvgnd_1
XFILLER_23_165 VGND VGND VPWR VPWR sky130_fd_sc_hd__fill_2
XTAP_TAPCELL_ROW_16_127 VGND VPWR sky130_fd_sc_hd__tapvpwrvgnd_1
X_315_ net51 net49 net10 VGND VGND VPWR VPWR _041_ sky130_fd_sc_hd__mux2_1
X_177_ net4 VGND VGND VPWR VPWR _067_ sky130_fd_sc_hd__inv_2
X_246_ net1 req_num_again VGND VGND VPWR VPWR _136_ sky130_fd_sc_hd__or2_2
XTAP_TAPCELL_ROW_13_119 VGND VPWR sky130_fd_sc_hd__tapvpwrvgnd_1
X_229_ net18 rng_rd.mem\[3\]\[1\] VGND VGND VPWR VPWR _119_ sky130_fd_sc_hd__nor2_1
XFILLER_6_150 VGND VGND VPWR VPWR sky130_fd_sc_hd__fill_2
XFILLER_8_99 VGND VGND VPWR VPWR sky130_fd_sc_hd__fill_1
XFILLER_25_205 VPWR VGND VPWR VGND sky130_ef_sc_hd__decap_40_12
XFILLER_33_85 VPWR VGND VPWR VGND sky130_ef_sc_hd__decap_40_12
XFILLER_33_41 VPWR VGND VPWR VGND sky130_ef_sc_hd__decap_40_12
Xhold4 rng_dp.seed_sel_i\[0\] VGND VGND VPWR VPWR net31 sky130_fd_sc_hd__dlygate4sd3_1
XFILLER_12_7 VGND VGND VPWR VPWR sky130_fd_sc_hd__fill_1
XFILLER_28_85 VPWR VGND VPWR VGND sky130_ef_sc_hd__decap_40_12
XFILLER_28_41 VPWR VGND VPWR VGND sky130_ef_sc_hd__decap_40_12
XPHY_EDGE_ROW_26_Right_26 VGND VGND VPWR VPWR sky130_fd_sc_hd__decap_3
XPHY_EDGE_ROW_17_Right_17 VGND VGND VPWR VPWR sky130_fd_sc_hd__decap_3
XFILLER_0_167 VGND VGND VPWR VPWR sky130_fd_sc_hd__fill_1
XFILLER_5_45 VGND VGND VPWR VPWR sky130_fd_sc_hd__fill_2
XFILLER_5_67 VGND VGND VPWR VPWR sky130_fd_sc_hd__fill_1
XFILLER_14_65 VGND VGND VPWR VPWR sky130_fd_sc_hd__fill_2
Xclkbuf_3_1__f_clk_i clknet_0_clk_i VGND VGND VPWR VPWR clknet_3_1__leaf_clk_i sky130_fd_sc_hd__clkbuf_16
XFILLER_30_97 VPWR VGND VPWR VGND sky130_ef_sc_hd__decap_40_12
XFILLER_30_53 VPWR VGND VPWR VGND sky130_ef_sc_hd__decap_40_12
XFILLER_29_193 VPWR VGND VPWR VGND sky130_ef_sc_hd__decap_40_12
XTAP_TAPCELL_ROW_28_169 VGND VPWR sky130_fd_sc_hd__tapvpwrvgnd_1
XFILLER_26_141 VPWR VGND VPWR VGND sky130_ef_sc_hd__decap_40_12
XFILLER_18_119 VGND VGND VPWR VPWR sky130_fd_sc_hd__fill_1
X_193_ _058_ net18 _080_ _081_ rng_rd.vld\[7\] VGND VGND VPWR VPWR _083_ sky130_fd_sc_hd__o221a_1
X_331_ net86 rng_rd.mem\[8\]\[1\] net9 VGND VGND VPWR VPWR _055_ sky130_fd_sc_hd__mux2_1
X_262_ _142_ _145_ rng_dp.seed_sel_i\[0\] VGND VGND VPWR VPWR _146_ sky130_fd_sc_hd__o21ai_1
XFILLER_32_177 VPWR VGND VPWR VGND sky130_ef_sc_hd__decap_40_12
XFILLER_32_133 VGND VGND VPWR VPWR sky130_fd_sc_hd__fill_4
XFILLER_17_141 VGND VGND VPWR VPWR sky130_fd_sc_hd__fill_8
XFILLER_17_130 VGND VGND VPWR VPWR sky130_fd_sc_hd__fill_2
XFILLER_23_177 VPWR VGND VPWR VGND sky130_ef_sc_hd__decap_40_12
XFILLER_23_144 VGND VGND VPWR VPWR sky130_fd_sc_hd__fill_1
XFILLER_23_111 VGND VGND VPWR VPWR sky130_fd_sc_hd__fill_1
XFILLER_11_66 VGND VGND VPWR VPWR sky130_fd_sc_hd__fill_4
XFILLER_11_55 VGND VGND VPWR VPWR sky130_fd_sc_hd__fill_1
X_314_ net49 net45 net8 VGND VGND VPWR VPWR _040_ sky130_fd_sc_hd__mux2_1
XTAP_TAPCELL_ROW_16_128 VGND VPWR sky130_fd_sc_hd__tapvpwrvgnd_1
XFILLER_14_133 VGND VGND VPWR VPWR sky130_fd_sc_hd__fill_4
X_245_ _095_ _113_ _134_ VGND VGND VPWR VPWR _135_ sky130_fd_sc_hd__and3_1
X_176_ net31 VGND VGND VPWR VPWR _001_ sky130_fd_sc_hd__inv_2
XFILLER_20_169 VGND VGND VPWR VPWR sky130_fd_sc_hd__fill_1
XFILLER_20_147 VGND VGND VPWR VPWR sky130_fd_sc_hd__fill_1
XFILLER_11_103 VGND VGND VPWR VPWR sky130_fd_sc_hd__fill_1
XFILLER_22_65 VGND VGND VPWR VPWR sky130_fd_sc_hd__fill_1
XFILLER_11_136 VGND VGND VPWR VPWR sky130_fd_sc_hd__fill_2
XFILLER_0_3 VPWR VGND VPWR VGND sky130_ef_sc_hd__decap_40_12
XFILLER_8_23 VGND VGND VPWR VPWR sky130_fd_sc_hd__fill_4
XFILLER_33_3 VPWR VGND VPWR VGND sky130_ef_sc_hd__decap_40_12
XFILLER_25_217 VGND VGND VPWR VPWR sky130_fd_sc_hd__fill_4
X_228_ net18 rng_rd.mem\[3\]\[1\] VGND VGND VPWR VPWR _118_ sky130_fd_sc_hd__and2_1
XFILLER_6_195 VGND VGND VPWR VPWR sky130_fd_sc_hd__fill_1
XFILLER_33_97 VPWR VGND VPWR VGND sky130_ef_sc_hd__decap_40_12
XFILLER_33_53 VGND VGND VPWR VPWR sky130_fd_sc_hd__fill_2
XFILLER_22_209 VPWR VGND VPWR VGND sky130_ef_sc_hd__decap_40_12
Xhold5 rng_rd.vld\[0\] VGND VGND VPWR VPWR net32 sky130_fd_sc_hd__dlygate4sd3_1
XFILLER_3_165 VGND VGND VPWR VPWR sky130_fd_sc_hd__fill_2
XFILLER_0_113 VPWR VGND VPWR VGND sky130_ef_sc_hd__decap_40_12
XFILLER_28_97 VPWR VGND VPWR VGND sky130_ef_sc_hd__decap_40_12
XFILLER_28_53 VPWR VGND VPWR VGND sky130_ef_sc_hd__decap_40_12
XFILLER_30_65 VPWR VGND VPWR VGND sky130_ef_sc_hd__decap_40_12
XFILLER_29_161 VGND VGND VPWR VPWR sky130_fd_sc_hd__fill_4
XFILLER_27_109 VGND VGND VPWR VPWR sky130_fd_sc_hd__fill_2
XFILLER_26_197 VPWR VGND VPWR VGND sky130_ef_sc_hd__decap_40_12
XFILLER_26_153 VPWR VGND VPWR VGND sky130_ef_sc_hd__decap_40_12
X_192_ rng_rd.mem\[7\]\[0\] net15 rng_rd.mem\[7\]\[1\] net13 VGND VGND VPWR VPWR _082_
+ sky130_fd_sc_hd__o22a_1
X_261_ _064_ _065_ VGND VGND VPWR VPWR _145_ sky130_fd_sc_hd__nor2_1
X_330_ net84 net77 net11 VGND VGND VPWR VPWR _054_ sky130_fd_sc_hd__mux2_1
XFILLER_32_189 VGND VGND VPWR VPWR sky130_fd_sc_hd__fill_4
XFILLER_23_189 VPWR VGND VPWR VGND sky130_ef_sc_hd__decap_40_12
XFILLER_23_167 VGND VGND VPWR VPWR sky130_fd_sc_hd__fill_1
X_313_ net45 rng_rd.vld\[2\] net7 VGND VGND VPWR VPWR _039_ sky130_fd_sc_hd__mux2_1
XTAP_TAPCELL_ROW_16_129 VGND VPWR sky130_fd_sc_hd__tapvpwrvgnd_1
X_244_ _117_ _122_ _128_ _133_ VGND VGND VPWR VPWR _134_ sky130_fd_sc_hd__nor4_1
X_175_ rng_dp.inst.next_num_o\[1\] VGND VGND VPWR VPWR _066_ sky130_fd_sc_hd__inv_2
XTAP_TAPCELL_ROW_30_176 VGND VPWR sky130_fd_sc_hd__tapvpwrvgnd_1
XFILLER_20_126 VGND VGND VPWR VPWR sky130_fd_sc_hd__fill_2
XFILLER_26_3 VPWR VGND VPWR VGND sky130_ef_sc_hd__decap_40_12
X_227_ _115_ _116_ _114_ VGND VGND VPWR VPWR _117_ sky130_fd_sc_hd__and3b_1
XFILLER_6_152 VGND VGND VPWR VPWR sky130_fd_sc_hd__fill_1
XFILLER_17_66 VGND VGND VPWR VPWR sky130_fd_sc_hd__fill_8
XFILLER_30_221 VGND VGND VPWR VPWR sky130_fd_sc_hd__fill_2
Xhold6 rng_rd.mem\[11\]\[1\] VGND VGND VPWR VPWR net33 sky130_fd_sc_hd__dlygate4sd3_1
XFILLER_3_111 VGND VGND VPWR VPWR sky130_fd_sc_hd__fill_1
XFILLER_21_221 VGND VGND VPWR VPWR sky130_fd_sc_hd__fill_2
XPHY_EDGE_ROW_3_Right_3 VGND VGND VPWR VPWR sky130_fd_sc_hd__decap_3
XFILLER_28_65 VPWR VGND VPWR VGND sky130_ef_sc_hd__decap_40_12
XFILLER_12_210 VPWR VGND VPWR VGND sky130_ef_sc_hd__decap_40_12
XFILLER_0_169 VPWR VGND VPWR VGND sky130_ef_sc_hd__decap_40_12
XFILLER_0_125 VPWR VGND VPWR VGND sky130_ef_sc_hd__decap_40_12
XTAP_TAPCELL_ROW_5_90 VGND VPWR sky130_fd_sc_hd__tapvpwrvgnd_1
XFILLER_30_77 VGND VGND VPWR VPWR sky130_fd_sc_hd__fill_4
XFILLER_14_89 VGND VGND VPWR VPWR sky130_fd_sc_hd__fill_2
XFILLER_14_67 VGND VGND VPWR VPWR sky130_fd_sc_hd__fill_1
XFILLER_14_56 VGND VGND VPWR VPWR sky130_fd_sc_hd__fill_4
XFILLER_26_165 VPWR VGND VPWR VGND sky130_ef_sc_hd__decap_40_12
XFILLER_26_121 VPWR VGND VPWR VGND sky130_ef_sc_hd__decap_40_12
XFILLER_25_55 VGND VGND VPWR VPWR sky130_fd_sc_hd__fill_1
XFILLER_2_209 VPWR VGND VPWR VGND sky130_ef_sc_hd__decap_40_12
X_260_ rng_dp.inst.next_num_o\[0\] _140_ _143_ VGND VGND VPWR VPWR _144_ sky130_fd_sc_hd__a21oi_1
XTAP_TAPCELL_ROW_19_138 VGND VPWR sky130_fd_sc_hd__tapvpwrvgnd_1
XFILLER_17_132 VGND VGND VPWR VPWR sky130_fd_sc_hd__fill_1
X_191_ rng_rd.mem\[7\]\[2\] net16 VGND VGND VPWR VPWR _081_ sky130_fd_sc_hd__nor2_1
X_389_ clknet_3_5__leaf_clk_i _054_ net24 VGND VGND VPWR VPWR rng_rd.mem\[9\]\[0\]
+ sky130_fd_sc_hd__dfrtp_1
XTAP_TAPCELL_ROW_2_80 VGND VPWR sky130_fd_sc_hd__tapvpwrvgnd_1
X_312_ net50 net40 net7 VGND VGND VPWR VPWR _038_ sky130_fd_sc_hd__mux2_1
X_243_ _060_ rng_rd.mem\[5\]\[2\] _129_ _132_ VGND VGND VPWR VPWR _133_ sky130_fd_sc_hd__o211a_1
X_174_ rng_dp.inst.next_num_o\[2\] VGND VGND VPWR VPWR _065_ sky130_fd_sc_hd__inv_2
XTAP_TAPCELL_ROW_30_177 VGND VPWR sky130_fd_sc_hd__tapvpwrvgnd_1
XFILLER_20_138 VGND VGND VPWR VPWR sky130_fd_sc_hd__fill_2
XFILLER_22_45 VGND VGND VPWR VPWR sky130_fd_sc_hd__fill_2
XFILLER_19_3 VGND VGND VPWR VPWR sky130_fd_sc_hd__fill_1
X_226_ net14 rng_rd.mem\[1\]\[0\] _068_ net18 rng_rd.vld\[1\] VGND VGND VPWR VPWR
+ _116_ sky130_fd_sc_hd__o221a_1
XFILLER_10_193 VGND VGND VPWR VPWR sky130_fd_sc_hd__fill_2
XFILLER_33_55 VGND VGND VPWR VPWR sky130_fd_sc_hd__fill_1
XFILLER_3_101 VGND VGND VPWR VPWR sky130_fd_sc_hd__fill_8
XFILLER_3_167 VGND VGND VPWR VPWR sky130_fd_sc_hd__fill_1
Xhold7 rng_rd.vld\[11\] VGND VGND VPWR VPWR net34 sky130_fd_sc_hd__dlygate4sd3_1
XPHY_EDGE_ROW_29_Left_63 VGND VGND VPWR VPWR sky130_fd_sc_hd__decap_3
XPHY_EDGE_ROW_13_Left_47 VGND VGND VPWR VPWR sky130_fd_sc_hd__decap_3
X_209_ _096_ _097_ _098_ VGND VGND VPWR VPWR _099_ sky130_fd_sc_hd__or3b_1
XFILLER_0_81 VGND VGND VPWR VPWR sky130_fd_sc_hd__fill_2
XFILLER_28_77 VGND VGND VPWR VPWR sky130_fd_sc_hd__fill_4
XFILLER_12_222 VGND VGND VPWR VPWR sky130_fd_sc_hd__fill_1
XFILLER_0_137 VGND VGND VPWR VPWR sky130_fd_sc_hd__fill_2
XFILLER_5_15 VGND VGND VPWR VPWR sky130_fd_sc_hd__fill_4
XFILLER_5_37 VGND VGND VPWR VPWR sky130_fd_sc_hd__fill_8
XPHY_EDGE_ROW_22_Right_22 VGND VGND VPWR VPWR sky130_fd_sc_hd__decap_3
XPHY_EDGE_ROW_13_Right_13 VGND VGND VPWR VPWR sky130_fd_sc_hd__decap_3
XTAP_TAPCELL_ROW_5_91 VGND VPWR sky130_fd_sc_hd__tapvpwrvgnd_1
XPHY_EDGE_ROW_31_Right_31 VGND VGND VPWR VPWR sky130_fd_sc_hd__decap_3
XFILLER_26_133 VGND VGND VPWR VPWR sky130_fd_sc_hd__fill_4
XPHY_EDGE_ROW_16_Left_50 VGND VGND VPWR VPWR sky130_fd_sc_hd__decap_3
XFILLER_26_177 VPWR VGND VPWR VGND sky130_ef_sc_hd__decap_40_12
XTAP_TAPCELL_ROW_19_139 VGND VPWR sky130_fd_sc_hd__tapvpwrvgnd_1
X_190_ rng_rd.mem\[7\]\[2\] net16 VGND VGND VPWR VPWR _080_ sky130_fd_sc_hd__and2_1
XFILLER_2_27 VGND VGND VPWR VPWR sky130_fd_sc_hd__fill_1
XFILLER_1_221 VGND VGND VPWR VPWR sky130_fd_sc_hd__fill_2
X_388_ clknet_3_4__leaf_clk_i _053_ net21 VGND VGND VPWR VPWR rng_dp.inst.next_num_o\[2\]
+ sky130_fd_sc_hd__dfrtp_2
XTAP_TAPCELL_ROW_2_81 VGND VPWR sky130_fd_sc_hd__tapvpwrvgnd_1
X_242_ num_i_bar\[0\] _071_ _130_ _131_ rng_rd.vld\[5\] VGND VGND VPWR VPWR _132_
+ sky130_fd_sc_hd__o221a_1
X_311_ net40 net32 net7 VGND VGND VPWR VPWR _037_ sky130_fd_sc_hd__mux2_1
XFILLER_11_47 VGND VGND VPWR VPWR sky130_fd_sc_hd__fill_8
X_173_ rng_dp.inst.next_num_o\[0\] VGND VGND VPWR VPWR _064_ sky130_fd_sc_hd__inv_2
XPHY_EDGE_ROW_1_Left_35 VGND VGND VPWR VPWR sky130_fd_sc_hd__decap_3
XTAP_TAPCELL_ROW_30_178 VGND VPWR sky130_fd_sc_hd__tapvpwrvgnd_1
XTAP_TAPCELL_ROW_21_145 VGND VPWR sky130_fd_sc_hd__tapvpwrvgnd_1
XFILLER_11_128 VGND VGND VPWR VPWR sky130_fd_sc_hd__fill_8
X_225_ net14 rng_rd.mem\[1\]\[0\] _068_ net18 VGND VGND VPWR VPWR _115_ sky130_fd_sc_hd__a22o_1
Xclkbuf_3_4__f_clk_i clknet_0_clk_i VGND VGND VPWR VPWR clknet_3_4__leaf_clk_i sky130_fd_sc_hd__clkbuf_16
XFILLER_17_35 VGND VGND VPWR VPWR sky130_fd_sc_hd__fill_1
XFILLER_16_209 VPWR VGND VPWR VGND sky130_ef_sc_hd__decap_40_12
XFILLER_3_113 VPWR VGND VPWR VGND sky130_ef_sc_hd__decap_40_12
Xhold8 _047_ VGND VGND VPWR VPWR net35 sky130_fd_sc_hd__dlygate4sd3_1
XFILLER_31_3 VPWR VGND VPWR VGND sky130_ef_sc_hd__decap_40_12
XFILLER_21_201 VPWR VGND VPWR VGND sky130_ef_sc_hd__decap_40_12
X_208_ num_i_bar\[0\] _067_ net5 net13 rng_rd.vld\[0\] VGND VGND VPWR VPWR _098_ sky130_fd_sc_hd__o221a_1
XFILLER_0_105 VGND VGND VPWR VPWR sky130_fd_sc_hd__fill_2
XPHY_EDGE_ROW_30_Left_64 VGND VGND VPWR VPWR sky130_fd_sc_hd__decap_3
XFILLER_5_208 VPWR VGND VPWR VGND sky130_ef_sc_hd__decap_40_12
XFILLER_26_189 VGND VGND VPWR VPWR sky130_fd_sc_hd__fill_4
XFILLER_25_57 VPWR VGND VPWR VGND sky130_ef_sc_hd__decap_40_12
XFILLER_32_137 VGND VGND VPWR VPWR sky130_fd_sc_hd__fill_2
X_387_ clknet_3_4__leaf_clk_i _052_ net21 VGND VGND VPWR VPWR rng_dp.inst.next_num_o\[1\]
+ sky130_fd_sc_hd__dfrtp_4
XTAP_TAPCELL_ROW_33_187 VGND VPWR sky130_fd_sc_hd__tapvpwrvgnd_1
XFILLER_31_181 VPWR VGND VPWR VGND sky130_ef_sc_hd__decap_40_12
X_310_ net32 net7 VGND VGND VPWR VPWR _036_ sky130_fd_sc_hd__or2_1
XFILLER_14_137 VGND VGND VPWR VPWR sky130_fd_sc_hd__fill_2
X_241_ net18 rng_rd.mem\[5\]\[1\] VGND VGND VPWR VPWR _131_ sky130_fd_sc_hd__and2_1
X_172_ rng_rd.vld\[11\] VGND VGND VPWR VPWR _063_ sky130_fd_sc_hd__inv_2
XFILLER_9_141 VGND VGND VPWR VPWR sky130_fd_sc_hd__fill_2
XTAP_TAPCELL_ROW_30_179 VGND VPWR sky130_fd_sc_hd__tapvpwrvgnd_1
XFILLER_22_47 VGND VGND VPWR VPWR sky130_fd_sc_hd__fill_1
XTAP_TAPCELL_ROW_21_146 VGND VPWR sky130_fd_sc_hd__tapvpwrvgnd_1
X_224_ net17 rng_rd.mem\[1\]\[2\] VGND VGND VPWR VPWR _114_ sky130_fd_sc_hd__xnor2_1
XTAP_TAPCELL_ROW_12_113 VGND VPWR sky130_fd_sc_hd__tapvpwrvgnd_1
XFILLER_10_195 VGND VGND VPWR VPWR sky130_fd_sc_hd__fill_1
XFILLER_8_27 VGND VGND VPWR VPWR sky130_fd_sc_hd__fill_1
XFILLER_8_49 VGND VGND VPWR VPWR sky130_fd_sc_hd__fill_4
XFILLER_33_221 VGND VGND VPWR VPWR sky130_fd_sc_hd__fill_2
XFILLER_33_57 VPWR VGND VPWR VGND sky130_ef_sc_hd__decap_40_12
XFILLER_24_221 VGND VGND VPWR VPWR sky130_fd_sc_hd__fill_2
Xhold9 rng_rd.vld\[8\] VGND VGND VPWR VPWR net36 sky130_fd_sc_hd__dlygate4sd3_1
XFILLER_3_125 VPWR VGND VPWR VGND sky130_ef_sc_hd__decap_40_12
XFILLER_3_169 VPWR VGND VPWR VGND sky130_ef_sc_hd__decap_40_12
XFILLER_24_3 VPWR VGND VPWR VGND sky130_ef_sc_hd__decap_40_12
X_207_ num_i_bar\[0\] _067_ net5 net13 VGND VGND VPWR VPWR _097_ sky130_fd_sc_hd__a22o_1
XFILLER_21_213 VGND VGND VPWR VPWR sky130_fd_sc_hd__fill_8
XFILLER_0_139 VGND VGND VPWR VPWR sky130_fd_sc_hd__fill_1
XFILLER_0_83 VGND VGND VPWR VPWR sky130_fd_sc_hd__fill_1
XFILLER_14_48 VGND VGND VPWR VPWR sky130_fd_sc_hd__fill_1
XFILLER_14_26 VGND VGND VPWR VPWR sky130_fd_sc_hd__fill_2
XPHY_EDGE_ROW_7_Right_7 VGND VGND VPWR VPWR sky130_fd_sc_hd__decap_3
XFILLER_29_165 VGND VGND VPWR VPWR sky130_fd_sc_hd__fill_2
XFILLER_20_80 VGND VGND VPWR VPWR sky130_fd_sc_hd__fill_1
XFILLER_6_82 VGND VGND VPWR VPWR sky130_fd_sc_hd__fill_2
XFILLER_25_69 VPWR VGND VPWR VGND sky130_ef_sc_hd__decap_40_12
X_386_ clknet_3_1__leaf_clk_i _051_ net21 VGND VGND VPWR VPWR rng_dp.inst.next_num_o\[0\]
+ sky130_fd_sc_hd__dfrtp_4
XTAP_TAPCELL_ROW_33_188 VGND VPWR sky130_fd_sc_hd__tapvpwrvgnd_1
XFILLER_31_193 VPWR VGND VPWR VGND sky130_ef_sc_hd__decap_40_12
XFILLER_23_105 VGND VGND VPWR VPWR sky130_fd_sc_hd__fill_4
XTAP_TAPCELL_ROW_24_155 VGND VPWR sky130_fd_sc_hd__tapvpwrvgnd_1
XFILLER_22_193 VGND VGND VPWR VPWR sky130_fd_sc_hd__fill_2
X_240_ net18 rng_rd.mem\[5\]\[1\] VGND VGND VPWR VPWR _130_ sky130_fd_sc_hd__nor2_1
X_171_ rng_rd.mem\[10\]\[1\] VGND VGND VPWR VPWR _062_ sky130_fd_sc_hd__inv_2
XFILLER_20_108 VPWR VGND VPWR VGND sky130_ef_sc_hd__decap_40_12
XFILLER_3_94 VGND VGND VPWR VPWR sky130_fd_sc_hd__fill_1
X_369_ clknet_3_0__leaf_clk_i _035_ net20 VGND VGND VPWR VPWR net6 sky130_fd_sc_hd__dfrtp_1
XFILLER_22_15 VPWR VGND VPWR VGND sky130_ef_sc_hd__decap_40_12
XTAP_TAPCELL_ROW_21_147 VGND VPWR sky130_fd_sc_hd__tapvpwrvgnd_1
XTAP_TAPCELL_ROW_12_114 VGND VPWR sky130_fd_sc_hd__tapvpwrvgnd_1
X_223_ _099_ _104_ _108_ _112_ VGND VGND VPWR VPWR _113_ sky130_fd_sc_hd__and4_1
XFILLER_33_69 VPWR VGND VPWR VGND sky130_ef_sc_hd__decap_40_12
XFILLER_17_15 VPWR VGND VPWR VGND sky130_ef_sc_hd__decap_40_12
XFILLER_3_137 VPWR VGND VPWR VGND sky130_ef_sc_hd__decap_40_12
X_206_ net17 net6 VGND VGND VPWR VPWR _096_ sky130_fd_sc_hd__xor2_1
XFILLER_17_3 VPWR VGND VPWR VGND sky130_ef_sc_hd__decap_40_12
XFILLER_0_107 VGND VGND VPWR VPWR sky130_fd_sc_hd__fill_1
XFILLER_18_91 VGND VGND VPWR VPWR sky130_fd_sc_hd__fill_1
XFILLER_30_15 VPWR VGND VPWR VGND sky130_ef_sc_hd__decap_40_12
XFILLER_29_111 VGND VGND VPWR VPWR sky130_fd_sc_hd__fill_1
XFILLER_4_221 VGND VGND VPWR VPWR sky130_fd_sc_hd__fill_2
XFILLER_25_15 VPWR VGND VPWR VGND sky130_ef_sc_hd__decap_40_12
XFILLER_32_139 VGND VGND VPWR VPWR sky130_fd_sc_hd__fill_1
XFILLER_17_169 VGND VGND VPWR VPWR sky130_fd_sc_hd__fill_4
XFILLER_15_92 VGND VGND VPWR VPWR sky130_fd_sc_hd__fill_4
XFILLER_15_70 VGND VGND VPWR VPWR sky130_fd_sc_hd__fill_2
X_385_ clknet_3_1__leaf_clk_i net29 net21 VGND VGND VPWR VPWR rng_rd.wr_ff2_d sky130_fd_sc_hd__dfrtp_1
XTAP_TAPCELL_ROW_33_189 VGND VPWR sky130_fd_sc_hd__tapvpwrvgnd_1
XFILLER_31_161 VGND VGND VPWR VPWR sky130_fd_sc_hd__fill_4
XTAP_TAPCELL_ROW_24_156 VGND VPWR sky130_fd_sc_hd__tapvpwrvgnd_1
XFILLER_14_139 VGND VGND VPWR VPWR sky130_fd_sc_hd__fill_1
X_170_ rng_rd.mem\[9\]\[0\] VGND VGND VPWR VPWR _061_ sky130_fd_sc_hd__inv_2
XFILLER_28_209 VPWR VGND VPWR VGND sky130_ef_sc_hd__decap_40_12
X_299_ net57 net62 net12 VGND VGND VPWR VPWR _025_ sky130_fd_sc_hd__mux2_1
X_368_ clknet_3_0__leaf_clk_i _034_ net22 VGND VGND VPWR VPWR net5 sky130_fd_sc_hd__dfrtp_1
XFILLER_3_40 VGND VGND VPWR VPWR sky130_fd_sc_hd__fill_2
XFILLER_3_73 VGND VGND VPWR VPWR sky130_fd_sc_hd__fill_4
XPHY_EDGE_ROW_29_Right_29 VGND VGND VPWR VPWR sky130_fd_sc_hd__decap_3
XFILLER_22_27 VGND VGND VPWR VPWR sky130_fd_sc_hd__fill_1
XFILLER_19_209 VPWR VGND VPWR VGND sky130_ef_sc_hd__decap_40_12
XPHY_EDGE_ROW_5_Left_39 VGND VGND VPWR VPWR sky130_fd_sc_hd__decap_3
XTAP_TAPCELL_ROW_12_115 VGND VPWR sky130_fd_sc_hd__tapvpwrvgnd_1
XFILLER_12_82 VGND VGND VPWR VPWR sky130_fd_sc_hd__fill_2
XFILLER_10_175 VGND VGND VPWR VPWR sky130_fd_sc_hd__fill_1
X_222_ _109_ _110_ _111_ VGND VGND VPWR VPWR _112_ sky130_fd_sc_hd__or3b_1
XFILLER_33_15 VPWR VGND VPWR VGND sky130_ef_sc_hd__decap_40_12
XFILLER_17_27 VGND VGND VPWR VPWR sky130_fd_sc_hd__fill_8
X_205_ _078_ _084_ _089_ _094_ VGND VGND VPWR VPWR _095_ sky130_fd_sc_hd__nor4_1
XFILLER_3_149 VPWR VGND VPWR VGND sky130_ef_sc_hd__decap_40_12
XFILLER_0_85 VPWR VGND VPWR VGND sky130_ef_sc_hd__decap_40_12
XFILLER_0_41 VPWR VGND VPWR VGND sky130_ef_sc_hd__decap_40_12
XFILLER_2_193 VGND VGND VPWR VPWR sky130_fd_sc_hd__fill_2
XFILLER_28_15 VPWR VGND VPWR VGND sky130_ef_sc_hd__decap_40_12
XPHY_EDGE_ROW_8_Left_42 VGND VGND VPWR VPWR sky130_fd_sc_hd__decap_3
XFILLER_30_27 VGND VGND VPWR VPWR sky130_fd_sc_hd__fill_1
XFILLER_29_167 VGND VGND VPWR VPWR sky130_fd_sc_hd__fill_1
XFILLER_14_39 VGND VGND VPWR VPWR sky130_fd_sc_hd__fill_1
XFILLER_26_137 VGND VGND VPWR VPWR sky130_fd_sc_hd__fill_2
XFILLER_25_27 VPWR VGND VPWR VGND sky130_ef_sc_hd__decap_40_12
XFILLER_25_181 VPWR VGND VPWR VGND sky130_ef_sc_hd__decap_40_12
X_384_ clknet_3_5__leaf_clk_i net61 net24 VGND VGND VPWR VPWR rng_rd.mem\[8\]\[2\]
+ sky130_fd_sc_hd__dfrtp_1
XFILLER_9_6 VGND VGND VPWR VPWR sky130_fd_sc_hd__fill_4
XFILLER_31_81 VPWR VGND VPWR VGND sky130_ef_sc_hd__decap_40_12
XFILLER_11_29 VGND VGND VPWR VPWR sky130_fd_sc_hd__fill_2
XTAP_TAPCELL_ROW_24_157 VGND VPWR sky130_fd_sc_hd__tapvpwrvgnd_1
XFILLER_22_195 VGND VGND VPWR VPWR sky130_fd_sc_hd__fill_1
Xclkbuf_3_7__f_clk_i clknet_0_clk_i VGND VGND VPWR VPWR clknet_3_7__leaf_clk_i sky130_fd_sc_hd__clkbuf_16
XFILLER_14_107 VGND VGND VPWR VPWR sky130_fd_sc_hd__fill_1
XFILLER_7_3 VPWR VGND VPWR VGND sky130_ef_sc_hd__decap_40_12
XFILLER_26_81 VGND VGND VPWR VPWR sky130_fd_sc_hd__fill_2
XPHY_EDGE_ROW_21_Left_55 VGND VGND VPWR VPWR sky130_fd_sc_hd__decap_3
X_298_ rng_rd.mem\[3\]\[0\] net75 net7 VGND VGND VPWR VPWR _024_ sky130_fd_sc_hd__mux2_1
XTAP_TAPCELL_ROW_15_124 VGND VPWR sky130_fd_sc_hd__tapvpwrvgnd_1
XFILLER_13_184 VGND VGND VPWR VPWR sky130_fd_sc_hd__fill_1
XFILLER_13_173 VGND VGND VPWR VPWR sky130_fd_sc_hd__fill_4
X_367_ clknet_3_2__leaf_clk_i _033_ net22 VGND VGND VPWR VPWR net4 sky130_fd_sc_hd__dfrtp_1
XFILLER_27_221 VGND VGND VPWR VPWR sky130_fd_sc_hd__fill_2
XTAP_TAPCELL_ROW_12_116 VGND VPWR sky130_fd_sc_hd__tapvpwrvgnd_1
XFILLER_10_154 VGND VGND VPWR VPWR sky130_fd_sc_hd__fill_1
X_221_ num_i_bar\[0\] _061_ rng_rd.mem\[9\]\[1\] net13 rng_rd.vld\[9\] VGND VGND VPWR
+ VPWR _111_ sky130_fd_sc_hd__o221a_1
XFILLER_33_27 VGND VGND VPWR VPWR sky130_fd_sc_hd__fill_1
X_204_ net19 _062_ _090_ _093_ VGND VGND VPWR VPWR _094_ sky130_fd_sc_hd__o211a_1
XFILLER_0_97 VGND VGND VPWR VPWR sky130_fd_sc_hd__fill_8
XFILLER_0_53 VGND VGND VPWR VPWR sky130_fd_sc_hd__fill_2
XFILLER_28_27 VGND VGND VPWR VPWR sky130_fd_sc_hd__fill_1
XFILLER_18_71 VGND VGND VPWR VPWR sky130_fd_sc_hd__fill_4
XFILLER_22_3 VPWR VGND VPWR VGND sky130_ef_sc_hd__decap_40_12
XFILLER_14_29 VGND VGND VPWR VPWR sky130_fd_sc_hd__fill_1
XFILLER_29_113 VPWR VGND VPWR VGND sky130_ef_sc_hd__decap_40_12
XFILLER_29_81 VPWR VGND VPWR VGND sky130_ef_sc_hd__decap_40_12
XFILLER_6_85 VGND VGND VPWR VPWR sky130_fd_sc_hd__fill_4
XTAP_TAPCELL_ROW_27_166 VGND VPWR sky130_fd_sc_hd__tapvpwrvgnd_1
XFILLER_25_193 VPWR VGND VPWR VGND sky130_ef_sc_hd__decap_40_12
XFILLER_25_39 VPWR VGND VPWR VGND sky130_ef_sc_hd__decap_40_12
X_383_ clknet_3_7__leaf_clk_i _049_ net26 VGND VGND VPWR VPWR rng_rd.mem\[8\]\[1\]
+ sky130_fd_sc_hd__dfrtp_1
XFILLER_17_149 VGND VGND VPWR VPWR sky130_fd_sc_hd__fill_1
XFILLER_17_105 VGND VGND VPWR VPWR sky130_fd_sc_hd__fill_2
XFILLER_31_93 VPWR VGND VPWR VGND sky130_ef_sc_hd__decap_40_12
XTAP_TAPCELL_ROW_24_158 VGND VPWR sky130_fd_sc_hd__tapvpwrvgnd_1
XTAP_TAPCELL_ROW_15_125 VGND VPWR sky130_fd_sc_hd__tapvpwrvgnd_1
X_297_ net68 net64 net8 VGND VGND VPWR VPWR _023_ sky130_fd_sc_hd__mux2_1
X_366_ clknet_3_0__leaf_clk_i net28 net20 VGND VGND VPWR VPWR rng_rd.wr_ff2 sky130_fd_sc_hd__dfrtp_1
XFILLER_22_29 VPWR VGND VPWR VGND sky130_ef_sc_hd__decap_40_12
XFILLER_3_42 VGND VGND VPWR VPWR sky130_fd_sc_hd__fill_1
XFILLER_3_86 VGND VGND VPWR VPWR sky130_fd_sc_hd__fill_8
XFILLER_10_111 VGND VGND VPWR VPWR sky130_fd_sc_hd__fill_2
X_220_ num_i_bar\[0\] _061_ rng_rd.mem\[9\]\[1\] net13 VGND VGND VPWR VPWR _110_ sky130_fd_sc_hd__a22o_1
XFILLER_18_222 VGND VGND VPWR VPWR sky130_fd_sc_hd__fill_1
X_349_ clknet_3_6__leaf_clk_i _017_ net25 VGND VGND VPWR VPWR rng_rd.mem\[6\]\[2\]
+ sky130_fd_sc_hd__dfrtp_1
XFILLER_2_195 VGND VGND VPWR VPWR sky130_fd_sc_hd__fill_1
X_203_ net15 rng_rd.mem\[10\]\[0\] _091_ _092_ rng_rd.vld\[10\] VGND VGND VPWR VPWR
+ _093_ sky130_fd_sc_hd__o221a_1
XFILLER_30_29 VPWR VGND VPWR VGND sky130_ef_sc_hd__decap_40_12
XFILLER_29_169 VPWR VGND VPWR VGND sky130_ef_sc_hd__decap_40_12
XFILLER_29_125 VPWR VGND VPWR VGND sky130_ef_sc_hd__decap_40_12
XFILLER_29_93 VPWR VGND VPWR VGND sky130_ef_sc_hd__decap_40_12
Xhold60 _055_ VGND VGND VPWR VPWR net87 sky130_fd_sc_hd__dlygate4sd3_1
XFILLER_26_139 VGND VGND VPWR VPWR sky130_fd_sc_hd__fill_1
XFILLER_1_205 VPWR VGND VPWR VGND sky130_ef_sc_hd__decap_40_12
XFILLER_32_109 VPWR VGND VPWR VGND sky130_ef_sc_hd__decap_40_12
XTAP_TAPCELL_ROW_27_167 VGND VPWR sky130_fd_sc_hd__tapvpwrvgnd_1
XFILLER_25_161 VGND VGND VPWR VPWR sky130_fd_sc_hd__fill_4
XFILLER_23_109 VGND VGND VPWR VPWR sky130_fd_sc_hd__fill_2
XTAP_TAPCELL_ROW_18_134 VGND VPWR sky130_fd_sc_hd__tapvpwrvgnd_1
XFILLER_16_150 VGND VGND VPWR VPWR sky130_fd_sc_hd__fill_1
Xoutput4 net4 VGND VGND VPWR VPWR num_to_send_o[0] sky130_fd_sc_hd__buf_2
X_382_ clknet_3_7__leaf_clk_i _048_ net26 VGND VGND VPWR VPWR rng_rd.mem\[8\]\[0\]
+ sky130_fd_sc_hd__dfrtp_1
XFILLER_26_83 VGND VGND VPWR VPWR sky130_fd_sc_hd__fill_1
XFILLER_22_197 VPWR VGND VPWR VGND sky130_ef_sc_hd__decap_40_12
X_296_ rng_rd.mem\[4\]\[1\] net57 net12 VGND VGND VPWR VPWR _022_ sky130_fd_sc_hd__mux2_1
XTAP_TAPCELL_ROW_15_126 VGND VPWR sky130_fd_sc_hd__tapvpwrvgnd_1
X_365_ clknet_3_0__leaf_clk_i net79 net20 VGND VGND VPWR VPWR rng_rd.mem\[1\]\[2\]
+ sky130_fd_sc_hd__dfrtp_1
XFILLER_8_190 VGND VGND VPWR VPWR sky130_fd_sc_hd__fill_4
XPHY_EDGE_ROW_25_Right_25 VGND VGND VPWR VPWR sky130_fd_sc_hd__decap_3
X_348_ clknet_3_7__leaf_clk_i net72 net26 VGND VGND VPWR VPWR rng_rd.mem\[6\]\[1\]
+ sky130_fd_sc_hd__dfrtp_1
XPHY_EDGE_ROW_16_Right_16 VGND VGND VPWR VPWR sky130_fd_sc_hd__decap_3
X_279_ _146_ _159_ _160_ rng_dp.seed_sel_i\[0\] rng_dp.seed_sel_i\[1\] VGND VGND VPWR
+ VPWR _161_ sky130_fd_sc_hd__a32o_1
XFILLER_33_29 VPWR VGND VPWR VGND sky130_ef_sc_hd__decap_40_12
XFILLER_23_51 VGND VGND VPWR VPWR sky130_fd_sc_hd__fill_4
XFILLER_2_141 VPWR VGND VPWR VGND sky130_ef_sc_hd__decap_40_12
X_202_ net16 rng_rd.mem\[10\]\[2\] VGND VGND VPWR VPWR _092_ sky130_fd_sc_hd__nor2_1
XFILLER_28_29 VPWR VGND VPWR VGND sky130_ef_sc_hd__decap_40_12
XFILLER_0_55 VGND VGND VPWR VPWR sky130_fd_sc_hd__fill_1
XFILLER_29_137 VPWR VGND VPWR VGND sky130_ef_sc_hd__decap_40_12
XPHY_EDGE_ROW_2_Right_2 VGND VGND VPWR VPWR sky130_fd_sc_hd__decap_3
XFILLER_20_85 VGND VGND VPWR VPWR sky130_fd_sc_hd__fill_4
Xhold50 rng_rd.mem\[8\]\[0\] VGND VGND VPWR VPWR net77 sky130_fd_sc_hd__dlygate4sd3_1
Xhold61 rng_rd.mem\[10\]\[1\] VGND VGND VPWR VPWR net88 sky130_fd_sc_hd__dlygate4sd3_1
XFILLER_1_217 VGND VGND VPWR VPWR sky130_fd_sc_hd__fill_4
XFILLER_31_51 VGND VGND VPWR VPWR sky130_fd_sc_hd__fill_4
XTAP_TAPCELL_ROW_27_168 VGND VPWR sky130_fd_sc_hd__tapvpwrvgnd_1
XFILLER_15_96 VGND VGND VPWR VPWR sky130_fd_sc_hd__fill_2
Xoutput5 net5 VGND VGND VPWR VPWR num_to_send_o[1] sky130_fd_sc_hd__buf_2
X_381_ clknet_3_4__leaf_clk_i net35 net24 VGND VGND VPWR VPWR rng_rd.vld\[11\] sky130_fd_sc_hd__dfrtp_1
XFILLER_31_165 VGND VGND VPWR VPWR sky130_fd_sc_hd__fill_2
XTAP_TAPCELL_ROW_18_135 VGND VPWR sky130_fd_sc_hd__tapvpwrvgnd_1
XFILLER_16_195 VGND VGND VPWR VPWR sky130_fd_sc_hd__fill_1
XTAP_TAPCELL_ROW_9_103 VGND VPWR sky130_fd_sc_hd__tapvpwrvgnd_1
X_295_ rng_rd.mem\[4\]\[0\] net92 net12 VGND VGND VPWR VPWR _021_ sky130_fd_sc_hd__mux2_1
X_364_ clknet_3_2__leaf_clk_i _031_ net22 VGND VGND VPWR VPWR rng_rd.mem\[1\]\[1\]
+ sky130_fd_sc_hd__dfrtp_1
XFILLER_13_110 VGND VGND VPWR VPWR sky130_fd_sc_hd__fill_2
XFILLER_3_11 VGND VGND VPWR VPWR sky130_fd_sc_hd__fill_2
XFILLER_3_55 VGND VGND VPWR VPWR sky130_fd_sc_hd__fill_1
XFILLER_3_77 VGND VGND VPWR VPWR sky130_fd_sc_hd__fill_1
XPHY_EDGE_ROW_25_Left_59 VGND VGND VPWR VPWR sky130_fd_sc_hd__decap_3
X_347_ clknet_3_6__leaf_clk_i net83 net25 VGND VGND VPWR VPWR rng_rd.mem\[6\]\[0\]
+ sky130_fd_sc_hd__dfrtp_1
XTAP_TAPCELL_ROW_20_141 VGND VPWR sky130_fd_sc_hd__tapvpwrvgnd_1
X_278_ rng_dp.inst.next_num_o\[2\] rng_dp.seed_sel_i\[1\] VGND VGND VPWR VPWR _160_
+ sky130_fd_sc_hd__nand2_1
XFILLER_5_3 VPWR VGND VPWR VGND sky130_ef_sc_hd__decap_40_12
XFILLER_3_109 VGND VGND VPWR VPWR sky130_fd_sc_hd__fill_2
XFILLER_2_153 VPWR VGND VPWR VGND sky130_ef_sc_hd__decap_40_12
XFILLER_2_197 VPWR VGND VPWR VGND sky130_ef_sc_hd__decap_40_12
X_201_ net16 rng_rd.mem\[10\]\[2\] VGND VGND VPWR VPWR _091_ sky130_fd_sc_hd__and2_1
Xclkbuf_3_0__f_clk_i clknet_0_clk_i VGND VGND VPWR VPWR clknet_3_0__leaf_clk_i sky130_fd_sc_hd__clkbuf_16
XFILLER_9_10 VGND VGND VPWR VPWR sky130_fd_sc_hd__fill_2
XFILLER_9_21 VGND VGND VPWR VPWR sky130_fd_sc_hd__fill_4
XFILLER_9_54 VGND VGND VPWR VPWR sky130_fd_sc_hd__fill_2
XPHY_EDGE_ROW_28_Left_62 VGND VGND VPWR VPWR sky130_fd_sc_hd__decap_3
XFILLER_7_212 VGND VGND VPWR VPWR sky130_fd_sc_hd__fill_8
XFILLER_29_149 VPWR VGND VPWR VGND sky130_ef_sc_hd__decap_40_12
XFILLER_29_105 VGND VGND VPWR VPWR sky130_fd_sc_hd__fill_4
XPHY_EDGE_ROW_12_Left_46 VGND VGND VPWR VPWR sky130_fd_sc_hd__decap_3
XFILLER_29_51 VGND VGND VPWR VPWR sky130_fd_sc_hd__fill_4
XFILLER_28_193 VGND VGND VPWR VPWR sky130_fd_sc_hd__fill_2
Xhold40 _009_ VGND VGND VPWR VPWR net67 sky130_fd_sc_hd__dlygate4sd3_1
Xhold62 net4 VGND VGND VPWR VPWR net89 sky130_fd_sc_hd__dlygate4sd3_1
Xhold51 rng_rd.mem\[1\]\[2\] VGND VGND VPWR VPWR net78 sky130_fd_sc_hd__dlygate4sd3_1
XFILLER_20_3 VPWR VGND VPWR VGND sky130_ef_sc_hd__decap_40_12
XFILLER_6_33 VPWR VGND VPWR VGND sky130_ef_sc_hd__decap_40_12
Xoutput6 net6 VGND VGND VPWR VPWR num_to_send_o[2] sky130_fd_sc_hd__buf_2
XTAP_TAPCELL_ROW_2_78 VGND VPWR sky130_fd_sc_hd__tapvpwrvgnd_1
X_380_ clknet_3_4__leaf_clk_i net39 net24 VGND VGND VPWR VPWR rng_rd.vld\[10\] sky130_fd_sc_hd__dfrtp_1
XFILLER_31_111 VGND VGND VPWR VPWR sky130_fd_sc_hd__fill_1
XTAP_TAPCELL_ROW_18_136 VGND VPWR sky130_fd_sc_hd__tapvpwrvgnd_1
.ends
